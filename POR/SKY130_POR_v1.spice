** sch_path: /home/nithin/eda/SKY130_DESIGN_IPS/POR/SKY130_POR_v1.sch
**.subckt SKY130_POR_v1
XM1 IBIAS_P IBIAS_P VDDA VDD sky130_fd_pr__pfet_01v8 L=1 W=1.5 nf=1 ad=0.435 as=0.435 pd=3.58 ps=3.58 nrd=0.193333333333333
+ nrs=0.193333333333333 sa=0 sb=0 sd=0 mult=10 m=10
XM2 IBIAS_N IBIAS_P VDDA VDD sky130_fd_pr__pfet_01v8 L=1 W=1.5 nf=1 ad=0.435 as=0.435 pd=3.58 ps=3.58 nrd=0.193333333333333
+ nrs=0.193333333333333 sa=0 sb=0 sd=0 mult=1
XM3 IBIAS_N IBIAS_N GNDA GND sky130_fd_pr__nfet_01v8 L=2 W=0.5 nf=1 ad=0.145 as=0.145 pd=1.58 ps=1.58 nrd=0.58 nrs=0.58 sa=0 sb=0
+ sd=0 mult=1
XM4 net3 IBIAS_N net1 GND sky130_fd_pr__nfet_01v8 L=2 W=0.5 nf=1 ad=0.145 as=0.145 pd=1.58 ps=1.58 nrd=0.58 nrs=0.58 sa=0 sb=0
+ sd=0 mult=4 m=4
XM5 net4 IBIAS_P VDDA VDD sky130_fd_pr__pfet_01v8 L=1 W=1.5 nf=1 ad=0.435 as=0.435 pd=3.58 ps=3.58 nrd=0.193333333333333
+ nrs=0.193333333333333 sa=0 sb=0 sd=0 mult=1
XM6 net2 V_DECISION VDDA VDD sky130_fd_pr__pfet_01v8 L=0.15 W=1 nf=1 ad=0.29 as=0.29 pd=2.58 ps=2.58 nrd=0.29 nrs=0.29 sa=0 sb=0
+ sd=0 mult=3 m=3
XM8 net2 V_DECISION GNDA GND sky130_fd_pr__nfet_01v8 L=0.15 W=1 nf=1 ad=0.29 as=0.29 pd=2.58 ps=2.58 nrd=0.29 nrs=0.29 sa=0 sb=0
+ sd=0 mult=1
XM7 V_POR net2 VDDA VDD sky130_fd_pr__pfet_01v8 L=0.15 W=1 nf=1 ad=0.29 as=0.29 pd=2.58 ps=2.58 nrd=0.29 nrs=0.29 sa=0 sb=0 sd=0
+ mult=3 m=3
XM9 V_POR net2 GNDA GND sky130_fd_pr__nfet_01v8 L=0.15 W=1 nf=1 ad=0.29 as=0.29 pd=2.58 ps=2.58 nrd=0.29 nrs=0.29 sa=0 sb=0 sd=0
+ mult=1
V1 VDDA 0 dc 1.5 PWL(0 0 10u 0v 100u 1.8 150u 1.8)
V2 GNDA 0 0
XM10 VDDA IBIAS_P VDDA VDD sky130_fd_pr__pfet_01v8 L=1 W=1 nf=1 ad=0.29 as=0.29 pd=2.58 ps=2.58 nrd=0.29 nrs=0.29 sa=0 sb=0 sd=0
+ mult=10 m=10
XM11 GNDA V_DECISION GNDA GND sky130_fd_pr__nfet_01v8 L=1 W=1 nf=1 ad=0.29 as=0.29 pd=2.58 ps=2.58 nrd=0.29 nrs=0.29 sa=0 sb=0
+ sd=0 mult=10 m=10
Vmeas net4 V_DECISION 0
.save i(vmeas)
Vmeas1 V_DECISION net3 0
.save i(vmeas1)
XR3 net5 net1 GNDA sky130_fd_pr__res_xhigh_po_0p35 L=1.75 mult=1
XR2 net6 net5 GNDA sky130_fd_pr__res_xhigh_po_0p35 L=1.75 mult=1
XR4 net7 net6 GNDA sky130_fd_pr__res_xhigh_po_0p35 L=1.75 mult=1
XR5 net8 net7 GNDA sky130_fd_pr__res_xhigh_po_0p35 L=1.75 mult=1
XR6 net9 net8 GNDA sky130_fd_pr__res_xhigh_po_0p35 L=1.75 mult=1
XR7 net10 net9 GNDA sky130_fd_pr__res_xhigh_po_0p35 L=1.75 mult=1
XR8 net11 net10 GNDA sky130_fd_pr__res_xhigh_po_0p35 L=1.75 mult=1
XR9 net12 net11 GNDA sky130_fd_pr__res_xhigh_po_0p35 L=1.75 mult=1
XR10 net13 net12 GNDA sky130_fd_pr__res_xhigh_po_0p35 L=1.75 mult=1
XR11 GNDA net13 GNDA sky130_fd_pr__res_xhigh_po_0p35 L=1.75 mult=1
XR12 net14 IBIAS_P GNDA sky130_fd_pr__res_xhigh_po_0p35 L=2 mult=1
XR1 net15 net14 GNDA sky130_fd_pr__res_xhigh_po_0p35 L=2 mult=1
XR13 net16 net15 GNDA sky130_fd_pr__res_xhigh_po_0p35 L=2 mult=1
XR14 net17 net16 GNDA sky130_fd_pr__res_xhigh_po_0p35 L=2 mult=1
XR15 net18 net17 GNDA sky130_fd_pr__res_xhigh_po_0p35 L=2 mult=1
XR16 net19 net18 GNDA sky130_fd_pr__res_xhigh_po_0p35 L=2 mult=1
XR17 GNDA net19 GNDA sky130_fd_pr__res_xhigh_po_0p35 L=2 mult=1
**** begin user architecture code

.option wnflag=1 gmin=1e-18
.option savecurrents
.temp 27
.control
save all
op
write SKY130_POR_v1.raw
set appendwrite
tran 0.1u 150u uic
let Idiff= vmeas#branch-vmeas1#branch
plot v(V_POR) v(V_DECISION) v(VDDA)
plot v(V_POR) vs v(VDDA)
plot v(V_DECISION) vs v(VDDA)
plot vmeas#branch vmeas1#branch
plot Idiff
**wrdata /home/nithin/eda/SKY130_DEAIGN_IPS/POR/SKY130_POR_v1.txt v(V_POR) v(V_DECISION) v(VDDA) vmeas#branch vmeas1#branch
write SKY130_POR_v1.raw
.endc

.save @m.xm1.msky130_fd_pr__pfet_01v8[gm]
.save @m.xm1.msky130_fd_pr__pfet_01v8[gds]
.save @m.xm1.msky130_fd_pr__pfet_01v8[vth]
.save @m.xm1.msky130_fd_pr__pfet_01v8[vdsat]
.save @m.xm1.msky130_fd_pr__pfet_01v8[cgg]
.save @m.xm1.msky130_fd_pr__pfet_01v8[cgso]
.save @m.xm1.msky130_fd_pr__pfet_01v8[cgdo]
.save @m.xm2.msky130_fd_pr__pfet_01v8[gm]
.save @m.xm2.msky130_fd_pr__pfet_01v8[gds]
.save @m.xm2.msky130_fd_pr__pfet_01v8[vth]
.save @m.xm2.msky130_fd_pr__pfet_01v8[vdsat]
.save @m.xm2.msky130_fd_pr__pfet_01v8[cgg]
.save @m.xm2.msky130_fd_pr__pfet_01v8[cgso]
.save @m.xm2.msky130_fd_pr__pfet_01v8[cgdo]
.save @m.xm3.msky130_fd_pr__nfet_01v8[gm]
.save @m.xm3.msky130_fd_pr__nfet_01v8[gds]
.save @m.xm3.msky130_fd_pr__nfet_01v8[vth]
.save @m.xm3.msky130_fd_pr__nfet_01v8[vdsat]
.save @m.xm3.msky130_fd_pr__nfet_01v8[cgg]
.save @m.xm3.msky130_fd_pr__nfet_01v8[cgso]
.save @m.xm3.msky130_fd_pr__nfet_01v8[cgdo]
.save @m.xm4.msky130_fd_pr__nfet_01v8[gm]
.save @m.xm4.msky130_fd_pr__nfet_01v8[gds]
.save @m.xm4.msky130_fd_pr__nfet_01v8[vth]
.save @m.xm4.msky130_fd_pr__nfet_01v8[vdsat]
.save @m.xm4.msky130_fd_pr__nfet_01v8[cgg]
.save @m.xm4.msky130_fd_pr__nfet_01v8[cgso]
.save @m.xm4.msky130_fd_pr__nfet_01v8[cgdo]
.save @m.xm5.msky130_fd_pr__pfet_01v8[gm]
.save @m.xm5.msky130_fd_pr__pfet_01v8[gds]
.save @m.xm5.msky130_fd_pr__pfet_01v8[vth]
.save @m.xm5.msky130_fd_pr__pfet_01v8[vdsat]
.save @m.xm5.msky130_fd_pr__pfet_01v8[cgg]
.save @m.xm5.msky130_fd_pr__pfet_01v8[cgso]
.save @m.xm5.msky130_fd_pr__pfet_01v8[cgdo]
.save @m.xm6.msky130_fd_pr__pfet_01v8[gm]
.save @m.xm6.msky130_fd_pr__pfet_01v8[gds]
.save @m.xm6.msky130_fd_pr__pfet_01v8[vth]
.save @m.xm6.msky130_fd_pr__pfet_01v8[vdsat]
.save @m.xm6.msky130_fd_pr__pfet_01v8[cgg]
.save @m.xm6.msky130_fd_pr__pfet_01v8[cgso]
.save @m.xm6.msky130_fd_pr__pfet_01v8[cgdo]
.save @m.xm8.msky130_fd_pr__nfet_01v8[gm]
.save @m.xm8.msky130_fd_pr__nfet_01v8[gds]
.save @m.xm8.msky130_fd_pr__nfet_01v8[vth]
.save @m.xm8.msky130_fd_pr__nfet_01v8[vdsat]
.save @m.xm8.msky130_fd_pr__nfet_01v8[cgg]
.save @m.xm8.msky130_fd_pr__nfet_01v8[cgso]
.save @m.xm8.msky130_fd_pr__nfet_01v8[cgdo]
.save @m.xm7.msky130_fd_pr__pfet_01v8[gm]
.save @m.xm7.msky130_fd_pr__pfet_01v8[gds]
.save @m.xm7.msky130_fd_pr__pfet_01v8[vth]
.save @m.xm7.msky130_fd_pr__pfet_01v8[vdsat]
.save @m.xm7.msky130_fd_pr__pfet_01v8[cgg]
.save @m.xm7.msky130_fd_pr__pfet_01v8[cgso]
.save @m.xm7.msky130_fd_pr__pfet_01v8[cgdo]
.save @m.xm9.msky130_fd_pr__nfet_01v8[gm]
.save @m.xm9.msky130_fd_pr__nfet_01v8[gds]
.save @m.xm9.msky130_fd_pr__nfet_01v8[vth]
.save @m.xm9.msky130_fd_pr__nfet_01v8[vdsat]
.save @m.xm9.msky130_fd_pr__nfet_01v8[cgg]
.save @m.xm9.msky130_fd_pr__nfet_01v8[cgso]
.save @m.xm9.msky130_fd_pr__nfet_01v8[cgdo]
.save @m.xm10.msky130_fd_pr__pfet_01v8[gm]
.save @m.xm10.msky130_fd_pr__pfet_01v8[gds]
.save @m.xm10.msky130_fd_pr__pfet_01v8[vth]
.save @m.xm10.msky130_fd_pr__pfet_01v8[vdsat]
.save @m.xm10.msky130_fd_pr__pfet_01v8[cgg]
.save @m.xm10.msky130_fd_pr__pfet_01v8[cgso]
.save @m.xm10.msky130_fd_pr__pfet_01v8[cgdo]
.save @m.xm11.msky130_fd_pr__nfet_01v8[gm]
.save @m.xm11.msky130_fd_pr__nfet_01v8[gds]
.save @m.xm11.msky130_fd_pr__nfet_01v8[vth]
.save @m.xm11.msky130_fd_pr__nfet_01v8[vdsat]
.save @m.xm11.msky130_fd_pr__nfet_01v8[cgg]
.save @m.xm11.msky130_fd_pr__nfet_01v8[cgso]
.save @m.xm11.msky130_fd_pr__nfet_01v8[cgdo]

** opencircuitdesign pdks install
.lib /home/nithin/.ciel/sky130A/libs.tech/combined/sky130.lib.spice fs

**** end user architecture code
**.ends
.end
