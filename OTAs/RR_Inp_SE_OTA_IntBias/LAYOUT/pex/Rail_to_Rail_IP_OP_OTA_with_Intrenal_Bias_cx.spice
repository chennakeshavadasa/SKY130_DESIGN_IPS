* NGSPICE file created from Rail_to_Rail_IP_OP_OTA_with_Intrenal_Bias.ext - technology: sky130A

.subckt Rail_to_Rail_IP_OP_OTA_with_Intrenal_Bias VDD EN VINN VOUT VINP MN_TAIL_BIAS
+ GNDA
X0 VOUT VBP_CASC net4 VDD sky130_fd_pr__pfet_01v8 ad=0.0725 pd=0.79 as=0.145 ps=1.58 w=0.5 l=0.5
X1 net2 net8 GNDA GNDA sky130_fd_pr__nfet_01v8 ad=0.0725 pd=0.79 as=0.0725 ps=0.79 w=0.5 l=2
X2 VOUT VBP_CASC net4 VDD sky130_fd_pr__pfet_01v8 ad=0.0725 pd=0.79 as=0.0725 ps=0.79 w=0.5 l=0.5
X3 EN_B EN GNDA GNDA sky130_fd_pr__nfet_01v8 ad=0.29 pd=2.58 as=0.5 ps=3 w=1 l=0.15
X4 net7 VINN net2 VDD sky130_fd_pr__pfet_01v8_lvt ad=0.58 pd=4.29 as=0.58 ps=4.29 w=4 l=2
X5 VBP_CASC VBP_CASC a_5881_8265# VDD sky130_fd_pr__pfet_01v8 ad=0.145 pd=1.58 as=0.0525 ps=0.71 w=0.5 l=0.5
X6 VBP_TOP MN_TAIL_BIAS net12 GNDA sky130_fd_pr__nfet_01v8 ad=1.45 pd=10.29 as=1.45 ps=10.29 w=10 l=4
X7 net6 VINN net4 GNDA sky130_fd_pr__nfet_01v8_lvt ad=0.3625 pd=2.79 as=0.3625 ps=2.79 w=2.5 l=2
X8 net1 VINP net7 VDD sky130_fd_pr__pfet_01v8_lvt ad=1.16 pd=8.58 as=0.58 ps=4.29 w=4 l=2
X9 GNDA net8 net1 GNDA sky130_fd_pr__nfet_01v8 ad=0.0725 pd=0.79 as=0.0725 ps=0.79 w=0.5 l=2
X10 MN_TAIL_BIAS EN_B GNDA GNDA sky130_fd_pr__nfet_01v8 ad=0.145 pd=1.58 as=0.145 ps=1.58 w=0.5 l=6.4
X11 MN_TAIL_BIAS MN_TAIL_BIAS GNDA GNDA sky130_fd_pr__nfet_01v8 ad=1.45 pd=10.29 as=2.9 ps=20.58 w=10 l=4
X12 a_15904_6577# VDD a_15750_4519# GNDA sky130_fd_pr__nfet_01v8 ad=0.145 pd=1.58 as=0.145 ps=1.58 w=0.5 l=10
X13 GNDA net8 net6 GNDA sky130_fd_pr__nfet_01v8 ad=0.0725 pd=0.79 as=0.145 ps=1.58 w=0.5 l=2
X14 a_15596_6577# VDD a_15750_4519# GNDA sky130_fd_pr__nfet_01v8 ad=0.145 pd=1.58 as=0.145 ps=1.58 w=0.5 l=10
X15 net3 VBP_CASC net5 VDD sky130_fd_pr__pfet_01v8 ad=0.145 pd=1.58 as=0.0725 ps=0.79 w=0.5 l=0.5
X16 VOUT VBN_CASC net2 GNDA sky130_fd_pr__nfet_01v8 ad=0.145 pd=1.58 as=0.145 ps=1.58 w=0.5 l=0.5
X17 VDD net9 net9 VDD sky130_fd_pr__pfet_01v8 ad=0.29 pd=2.29 as=0.58 ps=4.58 w=2 l=2
X18 VDD net9 net7 VDD sky130_fd_pr__pfet_01v8 ad=0.29 pd=2.29 as=0.58 ps=4.58 w=2 l=2
X19 MN_TAIL_BIAS VBP_TOP VDD VDD sky130_fd_pr__pfet_01v8 ad=0.58 pd=4.58 as=0.29 ps=2.29 w=2 l=2
X20 net1 net8 GNDA GNDA sky130_fd_pr__nfet_01v8 ad=0.145 pd=1.58 as=0.0725 ps=0.79 w=0.5 l=2
X21 VDD net5 net4 VDD sky130_fd_pr__pfet_01v8 ad=0.29 pd=2.29 as=0.29 ps=2.29 w=2 l=2
X22 net14 VSTRP_IP VDD VDD sky130_fd_pr__pfet_01v8 ad=0.29 pd=2.58 as=0.5 ps=3 w=1 l=0.15
X23 net4 VINN net6 GNDA sky130_fd_pr__nfet_01v8_lvt ad=0.3625 pd=2.79 as=0.3625 ps=2.79 w=2.5 l=2
X24 net1 VINP net7 VDD sky130_fd_pr__pfet_01v8_lvt ad=0.58 pd=4.29 as=0.58 ps=4.29 w=4 l=2
X25 VBP_TOP MN_TAIL_BIAS net12 GNDA sky130_fd_pr__nfet_01v8 ad=1.45 pd=10.29 as=1.45 ps=10.29 w=10 l=4
X26 a_16212_6577# VDD a_16366_4519# GNDA sky130_fd_pr__nfet_01v8 ad=0.145 pd=1.58 as=0.145 ps=1.58 w=0.5 l=10
X27 a_11860_6329# VDD GNDA sky130_fd_pr__res_xhigh_po_1p41 l=7.05
X28 a_10726_6199# a_10348_4519# GNDA sky130_fd_pr__res_xhigh_po_1p41 l=6.4
X29 VDD net5 net3 VDD sky130_fd_pr__pfet_01v8 ad=0.29 pd=2.29 as=0.58 ps=4.58 w=2 l=2
X30 net1 net8 GNDA GNDA sky130_fd_pr__nfet_01v8 ad=0.0725 pd=0.79 as=0.0725 ps=0.79 w=0.5 l=2
X31 net2 VINN net7 VDD sky130_fd_pr__pfet_01v8_lvt ad=0.58 pd=4.29 as=0.58 ps=4.29 w=4 l=2
X32 VBP_TOP MN_TAIL_BIAS net12 GNDA sky130_fd_pr__nfet_01v8 ad=1.45 pd=10.29 as=1.45 ps=10.29 w=10 l=4
X33 net7 net9 VDD VDD sky130_fd_pr__pfet_01v8 ad=0.58 pd=4.58 as=0.29 ps=2.29 w=2 l=2
X34 net5 VBP_CASC net3 VDD sky130_fd_pr__pfet_01v8 ad=0.0725 pd=0.79 as=0.145 ps=1.58 w=0.5 l=0.5
X35 net6 VINP net3 GNDA sky130_fd_pr__nfet_01v8_lvt ad=0.3625 pd=2.79 as=0.3625 ps=2.79 w=2.5 l=2
X36 net1 VINP net7 VDD sky130_fd_pr__pfet_01v8_lvt ad=0.58 pd=4.29 as=0.58 ps=4.29 w=4 l=2
X37 VBN_CASC EN_B GNDA GNDA sky130_fd_pr__nfet_01v8 ad=0.29 pd=2.58 as=0.145 ps=1.29 w=1 l=2
X38 VBP_TOP MN_TAIL_BIAS net12 GNDA sky130_fd_pr__nfet_01v8 ad=1.45 pd=10.29 as=2.9 ps=20.58 w=10 l=4
X39 net4 net5 VDD VDD sky130_fd_pr__pfet_01v8 ad=0.29 pd=2.29 as=0.29 ps=2.29 w=2 l=2
X40 net1 VINP net7 VDD sky130_fd_pr__pfet_01v8_lvt ad=0.58 pd=4.29 as=0.58 ps=4.29 w=4 l=2
X41 GNDA EN_B net8 GNDA sky130_fd_pr__nfet_01v8 ad=0.145 pd=1.29 as=0.29 ps=2.58 w=1 l=1
X42 net7 VINN net2 VDD sky130_fd_pr__pfet_01v8_lvt ad=0.58 pd=4.29 as=0.58 ps=4.29 w=4 l=2
X43 net7 VINP net1 VDD sky130_fd_pr__pfet_01v8_lvt ad=0.58 pd=4.29 as=0.58 ps=4.29 w=4 l=2
X44 net4 VINN net6 GNDA sky130_fd_pr__nfet_01v8_lvt ad=0.3625 pd=2.79 as=0.3625 ps=2.79 w=2.5 l=2
X45 GNDA net8 net8 GNDA sky130_fd_pr__nfet_01v8 ad=0.0725 pd=0.79 as=0.145 ps=1.58 w=0.5 l=2
X46 net6 net8 GNDA GNDA sky130_fd_pr__nfet_01v8 ad=0.145 pd=1.58 as=0.0725 ps=0.79 w=0.5 l=2
X47 net3 VINP net6 GNDA sky130_fd_pr__nfet_01v8_lvt ad=0.3625 pd=2.79 as=0.3625 ps=2.79 w=2.5 l=2
X48 net12 MN_TAIL_BIAS VBP_TOP GNDA sky130_fd_pr__nfet_01v8 ad=2.9 pd=20.58 as=1.45 ps=10.29 w=10 l=4
X49 GNDA net8 net2 GNDA sky130_fd_pr__nfet_01v8 ad=0.0725 pd=0.79 as=0.145 ps=1.58 w=0.5 l=2
X50 a_5517_1601# VBN_CASC a_5375_1601# GNDA sky130_fd_pr__nfet_01v8 ad=0.0525 pd=0.71 as=0.0525 ps=0.71 w=0.5 l=0.5
X51 net4 VBP_CASC VOUT VDD sky130_fd_pr__pfet_01v8 ad=0.0725 pd=0.79 as=0.0725 ps=0.79 w=0.5 l=0.5
X52 a_5881_8265# VBP_CASC a_5739_8265# VDD sky130_fd_pr__pfet_01v8 ad=0.0525 pd=0.71 as=0.0525 ps=0.71 w=0.5 l=0.5
X53 net7 VINN net2 VDD sky130_fd_pr__pfet_01v8_lvt ad=0.58 pd=4.29 as=0.58 ps=4.29 w=4 l=2
X54 a_5091_1601# VBN_CASC a_4949_1601# GNDA sky130_fd_pr__nfet_01v8 ad=0.0525 pd=0.71 as=0.0525 ps=0.71 w=0.5 l=0.5
X55 net15 a_14506_4519# GNDA sky130_fd_pr__res_xhigh_po_1p41 l=7.05
X56 net4 VBP_CASC VOUT VDD sky130_fd_pr__pfet_01v8 ad=0.145 pd=1.58 as=0.0725 ps=0.79 w=0.5 l=0.5
X57 net2 VINN net7 VDD sky130_fd_pr__pfet_01v8_lvt ad=1.16 pd=8.58 as=0.58 ps=4.29 w=4 l=2
X58 net7 VINN net2 VDD sky130_fd_pr__pfet_01v8_lvt ad=0.58 pd=4.29 as=1.16 ps=8.58 w=4 l=2
X59 net12 MN_TAIL_BIAS VBP_TOP GNDA sky130_fd_pr__nfet_01v8 ad=1.45 pd=10.29 as=1.45 ps=10.29 w=10 l=4
X60 net6 net8 GNDA GNDA sky130_fd_pr__nfet_01v8 ad=0.145 pd=1.58 as=0.0725 ps=0.79 w=0.5 l=2
X61 VDD EN VBP_CASC VDD sky130_fd_pr__pfet_01v8 ad=0.58 pd=4.58 as=0.58 ps=4.58 w=2 l=2
X62 net12 MN_TAIL_BIAS VBP_TOP GNDA sky130_fd_pr__nfet_01v8 ad=2.9 pd=20.58 as=1.45 ps=10.29 w=10 l=4
X63 a_5659_1601# VBN_CASC a_5517_1601# GNDA sky130_fd_pr__nfet_01v8 ad=0.0525 pd=0.71 as=0.0525 ps=0.71 w=0.5 l=0.5
X64 net2 VINN net7 VDD sky130_fd_pr__pfet_01v8_lvt ad=0.58 pd=4.29 as=0.58 ps=4.29 w=4 l=2
X65 net2 VINN net7 VDD sky130_fd_pr__pfet_01v8_lvt ad=0.58 pd=4.29 as=0.58 ps=4.29 w=4 l=2
X66 VDD net9 net7 VDD sky130_fd_pr__pfet_01v8 ad=0.29 pd=2.29 as=0.29 ps=2.29 w=2 l=2
X67 GNDA net8 net6 GNDA sky130_fd_pr__nfet_01v8 ad=0.0725 pd=0.79 as=0.145 ps=1.58 w=0.5 l=2
X68 net3 VBP_CASC net5 VDD sky130_fd_pr__pfet_01v8 ad=0.0725 pd=0.79 as=0.0725 ps=0.79 w=0.5 l=0.5
X69 net7 VINN net2 VDD sky130_fd_pr__pfet_01v8_lvt ad=0.58 pd=4.29 as=0.58 ps=4.29 w=4 l=2
X70 net2 VINN net7 VDD sky130_fd_pr__pfet_01v8_lvt ad=0.58 pd=4.29 as=0.58 ps=4.29 w=4 l=2
X71 MN_TAIL_BIAS MN_TAIL_BIAS GNDA GNDA sky130_fd_pr__nfet_01v8 ad=1.45 pd=10.29 as=2.9 ps=20.58 w=10 l=4
X72 net12 MN_TAIL_BIAS VBP_TOP GNDA sky130_fd_pr__nfet_01v8 ad=1.45 pd=10.29 as=1.45 ps=10.29 w=10 l=4
X73 net3 VINP net6 GNDA sky130_fd_pr__nfet_01v8_lvt ad=0.3625 pd=2.79 as=0.3625 ps=2.79 w=2.5 l=2
X74 GNDA MN_TAIL_BIAS MN_TAIL_BIAS GNDA sky130_fd_pr__nfet_01v8 ad=2.9 pd=20.58 as=1.45 ps=10.29 w=10 l=4
X75 VBP_TOP MN_TAIL_BIAS net12 GNDA sky130_fd_pr__nfet_01v8 ad=1.45 pd=10.29 as=1.45 ps=10.29 w=10 l=4
X76 a_5801_1601# VBN_CASC a_5659_1601# GNDA sky130_fd_pr__nfet_01v8 ad=0.0525 pd=0.71 as=0.0525 ps=0.71 w=0.5 l=0.5
X77 GNDA MN_TAIL_BIAS MN_TAIL_BIAS GNDA sky130_fd_pr__nfet_01v8 ad=2.9 pd=20.58 as=1.45 ps=10.29 w=10 l=4
X78 VDD net5 net3 VDD sky130_fd_pr__pfet_01v8 ad=0.29 pd=2.29 as=0.29 ps=2.29 w=2 l=2
X79 VDD VBP_TOP VSTRP_IP VDD sky130_fd_pr__pfet_01v8 ad=0.29 pd=2.29 as=0.58 ps=4.58 w=2 l=2
X80 VSTRP_OUT net14 VDD VDD sky130_fd_pr__pfet_01v8 ad=0.29 pd=2.58 as=0.5 ps=3 w=1 l=0.15
X81 net7 VINN net2 VDD sky130_fd_pr__pfet_01v8_lvt ad=0.58 pd=4.29 as=0.58 ps=4.29 w=4 l=2
X82 net2 VINN net7 VDD sky130_fd_pr__pfet_01v8_lvt ad=0.58 pd=4.29 as=0.58 ps=4.29 w=4 l=2
X83 net7 VINP net1 VDD sky130_fd_pr__pfet_01v8_lvt ad=0.58 pd=4.29 as=0.58 ps=4.29 w=4 l=2
X84 a_11860_6329# a_12238_4519# GNDA sky130_fd_pr__res_xhigh_po_1p41 l=7.05
X85 net7 VINP net1 VDD sky130_fd_pr__pfet_01v8_lvt ad=0.58 pd=4.29 as=0.58 ps=4.29 w=4 l=2
X86 VDD VBP_TOP VBP_TOP VDD sky130_fd_pr__pfet_01v8 ad=0.29 pd=2.29 as=0.58 ps=4.58 w=2 l=2
X87 a_13372_6329# a_12994_4519# GNDA sky130_fd_pr__res_xhigh_po_1p41 l=7.05
X88 net6 VINP net3 GNDA sky130_fd_pr__nfet_01v8_lvt ad=0.3625 pd=2.79 as=0.3625 ps=2.79 w=2.5 l=2
X89 VBP_TOP MN_TAIL_BIAS net12 GNDA sky130_fd_pr__nfet_01v8 ad=1.45 pd=10.29 as=2.9 ps=20.58 w=10 l=4
X90 VBN_CASC VBN_CASC a_5801_1601# GNDA sky130_fd_pr__nfet_01v8 ad=0.145 pd=1.58 as=0.0525 ps=0.71 w=0.5 l=0.5
X91 a_5233_1601# VBN_CASC a_5091_1601# GNDA sky130_fd_pr__nfet_01v8 ad=0.0525 pd=0.71 as=0.0525 ps=0.71 w=0.5 l=0.5
X92 a_16520_6577# VDD a_16366_4519# GNDA sky130_fd_pr__nfet_01v8 ad=0.145 pd=1.58 as=0.145 ps=1.58 w=0.5 l=10
X93 net4 net5 VDD VDD sky130_fd_pr__pfet_01v8 ad=0.29 pd=2.29 as=0.29 ps=2.29 w=2 l=2
X94 net3 VBP_CASC net5 VDD sky130_fd_pr__pfet_01v8 ad=0.0725 pd=0.79 as=0.0725 ps=0.79 w=0.5 l=0.5
X95 net7 VINN net2 VDD sky130_fd_pr__pfet_01v8_lvt ad=0.58 pd=4.29 as=0.58 ps=4.29 w=4 l=2
X96 VBP_TOP MN_TAIL_BIAS net12 GNDA sky130_fd_pr__nfet_01v8 ad=1.45 pd=10.29 as=2.9 ps=20.58 w=10 l=4
X97 VDD EN net5 VDD sky130_fd_pr__pfet_01v8 ad=0.58 pd=4.58 as=0.58 ps=4.58 w=2 l=2
X98 VDD net9 net7 VDD sky130_fd_pr__pfet_01v8 ad=0.29 pd=2.29 as=0.29 ps=2.29 w=2 l=2
X99 VSTRP_IP VBP_TOP VDD VDD sky130_fd_pr__pfet_01v8 ad=0.29 pd=2.29 as=0.29 ps=2.29 w=2 l=2
X100 GNDA net8 net1 GNDA sky130_fd_pr__nfet_01v8 ad=0.0725 pd=0.79 as=0.0725 ps=0.79 w=0.5 l=2
X101 net3 VBP_CASC net5 VDD sky130_fd_pr__pfet_01v8 ad=0.145 pd=1.58 as=0.0725 ps=0.79 w=0.5 l=0.5
X102 VSTRP_OUT EN_B VDD VDD sky130_fd_pr__pfet_01v8 ad=0.29 pd=2.58 as=0.5 ps=3 w=1 l=0.15
X103 net1 VINP net7 VDD sky130_fd_pr__pfet_01v8_lvt ad=0.58 pd=4.29 as=0.58 ps=4.29 w=4 l=2
X104 a_5375_1601# VBN_CASC a_5233_1601# GNDA sky130_fd_pr__nfet_01v8 ad=0.0525 pd=0.71 as=0.0525 ps=0.71 w=0.5 l=0.5
X105 net3 VINP net6 GNDA sky130_fd_pr__nfet_01v8_lvt ad=0.725 pd=5.58 as=0.3625 ps=2.79 w=2.5 l=2
X106 net7 VINP net1 VDD sky130_fd_pr__pfet_01v8_lvt ad=0.58 pd=4.29 as=1.16 ps=8.58 w=4 l=2
X107 a_9214_6199# a_8836_4519# GNDA sky130_fd_pr__res_xhigh_po_1p41 l=6.4
X108 VOUT VBP_CASC net4 VDD sky130_fd_pr__pfet_01v8 ad=0.0725 pd=0.79 as=0.0725 ps=0.79 w=0.5 l=0.5
X109 net7 VINP net1 VDD sky130_fd_pr__pfet_01v8_lvt ad=0.58 pd=4.29 as=0.58 ps=4.29 w=4 l=2
X110 VDD net5 net4 VDD sky130_fd_pr__pfet_01v8 ad=0.29 pd=2.29 as=0.29 ps=2.29 w=2 l=2
X111 net7 net9 VDD VDD sky130_fd_pr__pfet_01v8 ad=0.29 pd=2.29 as=0.29 ps=2.29 w=2 l=2
X112 net1 VINP net7 VDD sky130_fd_pr__pfet_01v8_lvt ad=0.58 pd=4.29 as=0.58 ps=4.29 w=4 l=2
X113 net6 VINN net4 GNDA sky130_fd_pr__nfet_01v8_lvt ad=0.3625 pd=2.79 as=0.3625 ps=2.79 w=2.5 l=2
X114 net12 MN_TAIL_BIAS VBP_TOP GNDA sky130_fd_pr__nfet_01v8 ad=1.45 pd=10.29 as=1.45 ps=10.29 w=10 l=4
X115 net3 net5 VDD VDD sky130_fd_pr__pfet_01v8 ad=0.58 pd=4.58 as=0.29 ps=2.29 w=2 l=2
X116 net2 VINN net7 VDD sky130_fd_pr__pfet_01v8_lvt ad=0.58 pd=4.29 as=0.58 ps=4.29 w=4 l=2
X117 a_13372_6329# a_13750_4519# GNDA sky130_fd_pr__res_xhigh_po_1p41 l=7.05
X118 a_12616_6329# a_12238_4519# GNDA sky130_fd_pr__res_xhigh_po_1p41 l=7.05
X119 VDD VBP_TOP VSTRP_IP VDD sky130_fd_pr__pfet_01v8 ad=0.29 pd=2.29 as=0.29 ps=2.29 w=2 l=2
X120 net7 VINP net1 VDD sky130_fd_pr__pfet_01v8_lvt ad=0.58 pd=4.29 as=0.58 ps=4.29 w=4 l=2
X121 net1 net8 GNDA GNDA sky130_fd_pr__nfet_01v8 ad=0.0725 pd=0.79 as=0.0725 ps=0.79 w=0.5 l=2
X122 net12 MN_TAIL_BIAS VBP_TOP GNDA sky130_fd_pr__nfet_01v8 ad=2.9 pd=20.58 as=1.45 ps=10.29 w=10 l=4
X123 EN_B EN VDD VDD sky130_fd_pr__pfet_01v8 ad=0.29 pd=2.58 as=0.5 ps=3 w=1 l=0.15
X124 net4 net5 VDD VDD sky130_fd_pr__pfet_01v8 ad=0.29 pd=2.29 as=0.29 ps=2.29 w=2 l=2
X125 net1 VINP net7 VDD sky130_fd_pr__pfet_01v8_lvt ad=0.58 pd=4.29 as=0.58 ps=4.29 w=4 l=2
X126 net7 VINN net2 VDD sky130_fd_pr__pfet_01v8_lvt ad=0.58 pd=4.29 as=0.58 ps=4.29 w=4 l=2
X127 GNDA net8 net2 GNDA sky130_fd_pr__nfet_01v8 ad=0.0725 pd=0.79 as=0.0725 ps=0.79 w=0.5 l=2
X128 net4 VINN net6 GNDA sky130_fd_pr__nfet_01v8_lvt ad=0.725 pd=5.58 as=0.3625 ps=2.79 w=2.5 l=2
X129 net1 VBN_CASC net5 GNDA sky130_fd_pr__nfet_01v8 ad=0.145 pd=1.58 as=0.145 ps=1.58 w=0.5 l=0.5
X130 VDD VBP_TOP VSTRP_IP VDD sky130_fd_pr__pfet_01v8 ad=0.58 pd=4.58 as=0.29 ps=2.29 w=2 l=2
X131 net7 VINP net1 VDD sky130_fd_pr__pfet_01v8_lvt ad=0.58 pd=4.29 as=0.58 ps=4.29 w=4 l=2
X132 net2 net8 GNDA GNDA sky130_fd_pr__nfet_01v8 ad=0.145 pd=1.58 as=0.0725 ps=0.79 w=0.5 l=2
X133 VBN_CASC net9 VDD VDD sky130_fd_pr__pfet_01v8 ad=0.58 pd=4.58 as=0.29 ps=2.29 w=2 l=2
X134 VOUT VBP_CASC net4 VDD sky130_fd_pr__pfet_01v8 ad=0.0725 pd=0.79 as=0.145 ps=1.58 w=0.5 l=0.5
X135 VBP_TOP MN_TAIL_BIAS net12 GNDA sky130_fd_pr__nfet_01v8 ad=1.45 pd=10.29 as=2.9 ps=20.58 w=10 l=4
X136 GNDA net8 net6 GNDA sky130_fd_pr__nfet_01v8 ad=0.0725 pd=0.79 as=0.145 ps=1.58 w=0.5 l=2
X137 VSTRP_IP VDD a_15442_4519# GNDA sky130_fd_pr__nfet_01v8 ad=0.145 pd=1.58 as=0.145 ps=1.58 w=0.5 l=10
X138 net6 VINN net4 GNDA sky130_fd_pr__nfet_01v8_lvt ad=0.3625 pd=2.79 as=0.3625 ps=2.79 w=2.5 l=2
X139 GNDA VDD a_16674_4519# GNDA sky130_fd_pr__nfet_01v8 ad=0.145 pd=1.58 as=0.145 ps=1.58 w=0.5 l=10
X140 net5 VBP_CASC net3 VDD sky130_fd_pr__pfet_01v8 ad=0.0725 pd=0.79 as=0.0725 ps=0.79 w=0.5 l=0.5
X141 net1 VINP net7 VDD sky130_fd_pr__pfet_01v8_lvt ad=0.58 pd=4.29 as=0.58 ps=4.29 w=4 l=2
X142 a_16520_6577# VDD a_16674_4519# GNDA sky130_fd_pr__nfet_01v8 ad=0.145 pd=1.58 as=0.145 ps=1.58 w=0.5 l=10
X143 a_10726_6199# a_11104_4519# GNDA sky130_fd_pr__res_xhigh_po_1p41 l=6.4
X144 net1 VINP net7 VDD sky130_fd_pr__pfet_01v8_lvt ad=0.58 pd=4.29 as=0.58 ps=4.29 w=4 l=2
X145 net14 VSTRP_IP GNDA GNDA sky130_fd_pr__nfet_01v8 ad=0.29 pd=2.58 as=0.5 ps=3 w=1 l=0.15
X146 net1 VINP net7 VDD sky130_fd_pr__pfet_01v8_lvt ad=1.16 pd=8.58 as=0.58 ps=4.29 w=4 l=2
X147 net12 MN_TAIL_BIAS VBP_TOP GNDA sky130_fd_pr__nfet_01v8 ad=1.45 pd=10.29 as=1.45 ps=10.29 w=10 l=4
X148 net2 net8 GNDA GNDA sky130_fd_pr__nfet_01v8 ad=0.0725 pd=0.79 as=0.0725 ps=0.79 w=0.5 l=2
X149 a_15904_6577# VDD a_16058_4519# GNDA sky130_fd_pr__nfet_01v8 ad=0.145 pd=1.58 as=0.145 ps=1.58 w=0.5 l=10
X150 net8 VBP_TOP VDD VDD sky130_fd_pr__pfet_01v8 ad=0.58 pd=4.58 as=0.29 ps=2.29 w=2 l=2
X151 net2 VINN net7 VDD sky130_fd_pr__pfet_01v8_lvt ad=0.58 pd=4.29 as=0.58 ps=4.29 w=4 l=2
X152 net9 EN VDD VDD sky130_fd_pr__pfet_01v8 ad=0.58 pd=4.58 as=0.58 ps=4.58 w=2 l=2
X153 net4 VBP_CASC VOUT VDD sky130_fd_pr__pfet_01v8 ad=0.145 pd=1.58 as=0.0725 ps=0.79 w=0.5 l=0.5
X154 net7 VINN net2 VDD sky130_fd_pr__pfet_01v8_lvt ad=0.58 pd=4.29 as=0.58 ps=4.29 w=4 l=2
X155 net7 VINN net2 VDD sky130_fd_pr__pfet_01v8_lvt ad=0.58 pd=4.29 as=0.58 ps=4.29 w=4 l=2
X156 VBP_TOP EN VDD VDD sky130_fd_pr__pfet_01v8 ad=0.145 pd=1.58 as=0.145 ps=1.58 w=0.5 l=1
X157 net5 VBN_CASC net1 GNDA sky130_fd_pr__nfet_01v8 ad=0.0725 pd=0.79 as=0.145 ps=1.58 w=0.5 l=0.5
X158 GNDA net8 net1 GNDA sky130_fd_pr__nfet_01v8 ad=0.0725 pd=0.79 as=0.145 ps=1.58 w=0.5 l=2
X159 a_14128_6329# a_13750_4519# GNDA sky130_fd_pr__res_xhigh_po_1p41 l=7.05
X160 net6 VINP net3 GNDA sky130_fd_pr__nfet_01v8_lvt ad=0.3625 pd=2.79 as=0.3625 ps=2.79 w=2.5 l=2
X161 net6 VINP net3 GNDA sky130_fd_pr__nfet_01v8_lvt ad=0.3625 pd=2.79 as=0.725 ps=5.58 w=2.5 l=2
X162 net2 VBN_CASC VOUT GNDA sky130_fd_pr__nfet_01v8 ad=0.0725 pd=0.79 as=0.145 ps=1.58 w=0.5 l=0.5
X163 VDD net9 net7 VDD sky130_fd_pr__pfet_01v8 ad=0.29 pd=2.29 as=0.58 ps=4.58 w=2 l=2
X164 VSTRP_IP VBP_TOP VDD VDD sky130_fd_pr__pfet_01v8 ad=0.29 pd=2.29 as=0.29 ps=2.29 w=2 l=2
X165 net1 VINP net7 VDD sky130_fd_pr__pfet_01v8_lvt ad=0.58 pd=4.29 as=0.58 ps=4.29 w=4 l=2
X166 GNDA net8 VBP_CASC GNDA sky130_fd_pr__nfet_01v8 ad=0.145 pd=1.58 as=0.145 ps=1.58 w=0.5 l=2
X167 net6 net8 GNDA GNDA sky130_fd_pr__nfet_01v8 ad=0.145 pd=1.58 as=0.0725 ps=0.79 w=0.5 l=2
X168 net2 VINN net7 VDD sky130_fd_pr__pfet_01v8_lvt ad=0.58 pd=4.29 as=0.58 ps=4.29 w=4 l=2
X169 net6 net8 GNDA GNDA sky130_fd_pr__nfet_01v8 ad=0.145 pd=1.58 as=0.0725 ps=0.79 w=0.5 l=2
X170 net2 VINN net7 VDD sky130_fd_pr__pfet_01v8_lvt ad=1.16 pd=8.58 as=0.58 ps=4.29 w=4 l=2
X171 net7 VINP net1 VDD sky130_fd_pr__pfet_01v8_lvt ad=0.58 pd=4.29 as=0.58 ps=4.29 w=4 l=2
X172 net7 VINN net2 VDD sky130_fd_pr__pfet_01v8_lvt ad=0.58 pd=4.29 as=0.58 ps=4.29 w=4 l=2
X173 VDD net5 net3 VDD sky130_fd_pr__pfet_01v8 ad=0.29 pd=2.29 as=0.29 ps=2.29 w=2 l=2
X174 net3 VINP net6 GNDA sky130_fd_pr__nfet_01v8_lvt ad=0.3625 pd=2.79 as=0.3625 ps=2.79 w=2.5 l=2
X175 net12 MN_TAIL_BIAS VBP_TOP GNDA sky130_fd_pr__nfet_01v8 ad=2.9 pd=20.58 as=1.45 ps=10.29 w=10 l=4
X176 net7 net9 VDD VDD sky130_fd_pr__pfet_01v8 ad=0.58 pd=4.58 as=0.29 ps=2.29 w=2 l=2
X177 net2 VINN net7 VDD sky130_fd_pr__pfet_01v8_lvt ad=0.58 pd=4.29 as=0.58 ps=4.29 w=4 l=2
X178 net4 VBP_CASC VOUT VDD sky130_fd_pr__pfet_01v8 ad=0.0725 pd=0.79 as=0.0725 ps=0.79 w=0.5 l=0.5
X179 net7 VINN net2 VDD sky130_fd_pr__pfet_01v8_lvt ad=0.58 pd=4.29 as=1.16 ps=8.58 w=4 l=2
X180 GNDA net8 net6 GNDA sky130_fd_pr__nfet_01v8 ad=0.0725 pd=0.79 as=0.145 ps=1.58 w=0.5 l=2
X181 a_8458_6199# net12 GNDA sky130_fd_pr__res_xhigh_po_1p41 l=6.4
X182 a_9214_6199# a_9592_4519# GNDA sky130_fd_pr__res_xhigh_po_1p41 l=6.4
X183 net5 VBP_CASC net3 VDD sky130_fd_pr__pfet_01v8 ad=0.0725 pd=0.79 as=0.145 ps=1.58 w=0.5 l=0.5
X184 VSTRP_IP VBP_TOP VDD VDD sky130_fd_pr__pfet_01v8 ad=0.29 pd=2.29 as=0.29 ps=2.29 w=2 l=2
X185 net6 VINN net4 GNDA sky130_fd_pr__nfet_01v8_lvt ad=0.3625 pd=2.79 as=0.725 ps=5.58 w=2.5 l=2
X186 a_15596_6577# VDD a_15442_4519# GNDA sky130_fd_pr__nfet_01v8 ad=0.145 pd=1.58 as=0.145 ps=1.58 w=0.5 l=10
X187 net7 net9 VDD VDD sky130_fd_pr__pfet_01v8 ad=0.29 pd=2.29 as=0.29 ps=2.29 w=2 l=2
X188 net2 VINN net7 VDD sky130_fd_pr__pfet_01v8_lvt ad=0.58 pd=4.29 as=0.58 ps=4.29 w=4 l=2
X189 net3 net5 VDD VDD sky130_fd_pr__pfet_01v8 ad=0.29 pd=2.29 as=0.29 ps=2.29 w=2 l=2
X190 VSTRP_OUT net14 a_16520_7509# GNDA sky130_fd_pr__nfet_01v8 ad=0.29 pd=2.58 as=0.5 ps=3 w=1 l=0.15
X191 net2 VINN net7 VDD sky130_fd_pr__pfet_01v8_lvt ad=0.58 pd=4.29 as=0.58 ps=4.29 w=4 l=2
X192 a_14128_6329# a_14506_4519# GNDA sky130_fd_pr__res_xhigh_po_1p41 l=7.05
X193 net7 VINP net1 VDD sky130_fd_pr__pfet_01v8_lvt ad=0.58 pd=4.29 as=0.58 ps=4.29 w=4 l=2
X194 net5 VBP_CASC net3 VDD sky130_fd_pr__pfet_01v8 ad=0.0725 pd=0.79 as=0.0725 ps=0.79 w=0.5 l=0.5
X195 net7 VINN net2 VDD sky130_fd_pr__pfet_01v8_lvt ad=0.58 pd=4.29 as=0.58 ps=4.29 w=4 l=2
X196 net7 VINN net2 VDD sky130_fd_pr__pfet_01v8_lvt ad=0.58 pd=4.29 as=0.58 ps=4.29 w=4 l=2
X197 net9 net8 GNDA GNDA sky130_fd_pr__nfet_01v8 ad=0.145 pd=1.58 as=0.0725 ps=0.79 w=0.5 l=2
X198 a_12616_6329# a_12994_4519# GNDA sky130_fd_pr__res_xhigh_po_1p41 l=7.05
X199 a_16212_6577# VDD a_16058_4519# GNDA sky130_fd_pr__nfet_01v8 ad=0.145 pd=1.58 as=0.145 ps=1.58 w=0.5 l=10
X200 VDD VBP_TOP net8 VDD sky130_fd_pr__pfet_01v8 ad=0.29 pd=2.29 as=0.58 ps=4.58 w=2 l=2
X201 net4 VINN net6 GNDA sky130_fd_pr__nfet_01v8_lvt ad=0.3625 pd=2.79 as=0.3625 ps=2.79 w=2.5 l=2
X202 VDD net5 net4 VDD sky130_fd_pr__pfet_01v8 ad=0.29 pd=2.29 as=0.29 ps=2.29 w=2 l=2
X203 VDD VBP_TOP VSTRP_IP VDD sky130_fd_pr__pfet_01v8 ad=0.29 pd=2.29 as=0.29 ps=2.29 w=2 l=2
X204 a_16520_7509# EN GNDA GNDA sky130_fd_pr__nfet_01v8 ad=0.29 pd=2.58 as=0.5 ps=3 w=1 l=0.15
X205 net7 VINP net1 VDD sky130_fd_pr__pfet_01v8_lvt ad=0.58 pd=4.29 as=0.58 ps=4.29 w=4 l=2
X206 net1 VINP net7 VDD sky130_fd_pr__pfet_01v8_lvt ad=0.58 pd=4.29 as=0.58 ps=4.29 w=4 l=2
X207 net2 VINN net7 VDD sky130_fd_pr__pfet_01v8_lvt ad=0.58 pd=4.29 as=0.58 ps=4.29 w=4 l=2
X208 net7 VINP net1 VDD sky130_fd_pr__pfet_01v8_lvt ad=0.58 pd=4.29 as=1.16 ps=8.58 w=4 l=2
X209 GNDA net8 net2 GNDA sky130_fd_pr__nfet_01v8 ad=0.0725 pd=0.79 as=0.0725 ps=0.79 w=0.5 l=2
X210 a_4949_1601# VBN_CASC GNDA GNDA sky130_fd_pr__nfet_01v8 ad=0.0525 pd=0.71 as=0.145 ps=1.58 w=0.5 l=0.5
X211 net1 VBN_CASC net5 GNDA sky130_fd_pr__nfet_01v8 ad=0.145 pd=1.58 as=0.0725 ps=0.79 w=0.5 l=0.5
X212 a_5739_8265# VBP_CASC VDD VDD sky130_fd_pr__pfet_01v8 ad=0.0525 pd=0.71 as=0.145 ps=1.58 w=0.5 l=0.5
X213 VOUT VBN_CASC net2 GNDA sky130_fd_pr__nfet_01v8 ad=0.145 pd=1.58 as=0.0725 ps=0.79 w=0.5 l=0.5
X214 net3 net5 VDD VDD sky130_fd_pr__pfet_01v8 ad=0.29 pd=2.29 as=0.29 ps=2.29 w=2 l=2
X215 net7 VINP net1 VDD sky130_fd_pr__pfet_01v8_lvt ad=0.58 pd=4.29 as=0.58 ps=4.29 w=4 l=2
X216 a_9970_6199# a_9592_4519# GNDA sky130_fd_pr__res_xhigh_po_1p41 l=6.4
X217 a_8458_6199# a_8836_4519# GNDA sky130_fd_pr__res_xhigh_po_1p41 l=6.4
X218 net1 VINP net7 VDD sky130_fd_pr__pfet_01v8_lvt ad=0.58 pd=4.29 as=0.58 ps=4.29 w=4 l=2
X219 net1 VINP net7 VDD sky130_fd_pr__pfet_01v8_lvt ad=0.58 pd=4.29 as=0.58 ps=4.29 w=4 l=2
X220 MN_TAIL_BIAS VSTRP_OUT net15 VDD sky130_fd_pr__pfet_01v8 ad=0.145 pd=1.58 as=0.145 ps=1.58 w=0.5 l=4
X221 GNDA a_11104_4519# GNDA sky130_fd_pr__res_xhigh_po_1p41 l=6.4
X222 a_9970_6199# a_10348_4519# GNDA sky130_fd_pr__res_xhigh_po_1p41 l=6.4
X223 net7 VINP net1 VDD sky130_fd_pr__pfet_01v8_lvt ad=0.58 pd=4.29 as=0.58 ps=4.29 w=4 l=2
X224 net7 VINP net1 VDD sky130_fd_pr__pfet_01v8_lvt ad=0.58 pd=4.29 as=0.58 ps=4.29 w=4 l=2
C0 a_8458_6199# net8 0
C1 net2 net6 1.33724f
C2 VOUT net9 0.09674f
C3 net3 a_5739_8265# 0
C4 VINP net6 3.22026f
C5 VOUT net8 0.53124f
C6 net2 VINN 12.0845f
C7 VDD net6 0.13722f
C8 VDD a_11860_6329# 0.16241f
C9 a_16212_6577# VDD 0.05182f
C10 a_11860_6329# EN_B 0.00728f
C11 a_16212_6577# EN_B 0
C12 VBN_CASC net5 0.57848f
C13 a_11860_6329# MN_TAIL_BIAS 0.01418f
C14 a_16058_4519# a_14506_4519# 0
C15 a_9214_6199# VBP_TOP 0.03457f
C16 VINP VINN 20.2339f
C17 net5 VBP_CASC 0.65889f
C18 VDD VINN 13.4799f
C19 net7 net3 0.02782f
C20 EN_B VINN 0
C21 MN_TAIL_BIAS VINN 0.00195f
C22 net1 VBN_CASC 0.33044f
C23 VDD VSTRP_OUT 2.39815f
C24 VSTRP_OUT EN_B 0.24133f
C25 VBP_TOP VSTRP_IP 1.1328f
C26 VDD a_12994_4519# 0.01508f
C27 VSTRP_OUT MN_TAIL_BIAS 0.2215f
C28 net1 VBP_CASC 0.13404f
C29 net9 net8 0.3269f
C30 a_12994_4519# MN_TAIL_BIAS 0.01513f
C31 net2 VINP 3.58972f
C32 VBN_CASC VBP_TOP 0.01335f
C33 a_14128_6329# a_13750_4519# 0.01317f
C34 a_13372_6329# VBP_TOP 0
C35 net2 VDD 4.69968f
C36 net7 EN 1.41463f
C37 VOUT net4 0.46691f
C38 VDD a_5881_8265# 0.00331f
C39 net1 net12 0
C40 net2 MN_TAIL_BIAS 0.01193f
C41 a_15904_6577# VSTRP_IP 0.00524f
C42 a_12616_6329# a_11860_6329# 0.29626f
C43 VINP VDD 17.8524f
C44 VBP_TOP net12 6.13805f
C45 a_15750_4519# a_16058_4519# 0.00823f
C46 VDD EN_B 3.61653f
C47 EN_B a_9970_6199# 0.00465f
C48 VBN_CASC a_4949_1601# 0.003f
C49 a_16520_7509# net15 0
C50 MN_TAIL_BIAS a_9970_6199# 0.00592f
C51 VDD MN_TAIL_BIAS 1.9398f
C52 EN_B MN_TAIL_BIAS 0.25789f
C53 VBN_CASC a_5233_1601# 0.00332f
C54 net2 a_8836_4519# 0
C55 net15 VSTRP_IP 0.45271f
C56 net4 net9 0.00232f
C57 net14 a_16520_6577# 0
C58 VBP_TOP a_10726_6199# 0.02047f
C59 a_12616_6329# a_12994_4519# 0.01317f
C60 a_13372_6329# net15 0.00542f
C61 net6 a_5091_1601# 0
C62 net7 net6 0.46156f
C63 VDD a_8836_4519# 0
C64 VOUT net5 2.94184f
C65 a_16366_4519# net12 0
C66 net4 net8 0
C67 a_8836_4519# MN_TAIL_BIAS 0.01278f
C68 a_8458_6199# VBP_TOP 0.00649f
C69 net7 VINN 11.1751f
C70 net1 VOUT 0.45578f
C71 VDD a_12616_6329# 0.02385f
C72 VDD a_5739_8265# 0.00502f
C73 a_12616_6329# EN_B 0.00836f
C74 VOUT VBP_TOP 0.00115f
C75 VBN_CASC net3 0.12551f
C76 a_16520_7509# EN 0.0476f
C77 net9 net5 0.06576f
C78 net2 a_5091_1601# 0.00107f
C79 net2 net7 13.1593f
C80 net3 VBP_CASC 0.86825f
C81 a_14128_6329# VBP_TOP 0
C82 EN VSTRP_IP 0.10385f
C83 net5 net8 0.20888f
C84 VINP a_5091_1601# 0
C85 net1 net9 0.11447f
C86 VBN_CASC EN 0.10924f
C87 VINP net7 10.6061f
C88 a_9970_6199# a_10348_4519# 0.01451f
C89 VDD a_10348_4519# 0
C90 VOUT a_4949_1601# 0
C91 VDD net7 8.97905f
C92 a_9592_4519# VBP_TOP 0.12536f
C93 MN_TAIL_BIAS a_10348_4519# 0.03174f
C94 VDD a_16058_4519# 0.05182f
C95 net7 EN_B 0.01622f
C96 VBN_CASC a_5375_1601# 0.0036f
C97 VBP_CASC EN 0.20212f
C98 VOUT a_5233_1601# 0
C99 net7 MN_TAIL_BIAS 0.03228f
C100 net1 net8 0.6262f
C101 net9 VBP_TOP 2.3028f
C102 MN_TAIL_BIAS a_16058_4519# 0
C103 a_16366_4519# a_16674_4519# 0.00823f
C104 VBP_TOP net8 0.44833f
C105 net7 a_8836_4519# 0.00636f
C106 a_14128_6329# net15 0.32721f
C107 net4 net5 2.04727f
C108 VDD a_11104_4519# 0.31007f
C109 a_16212_6577# VSTRP_IP 0.00262f
C110 a_15442_4519# VBP_TOP 0
C111 a_11104_4519# MN_TAIL_BIAS 0.1553f
C112 VBN_CASC net6 0.05256f
C113 a_16520_7509# VSTRP_OUT 0.17133f
C114 VBP_TOP a_13750_4519# 0.00266f
C115 net1 net4 0
C116 a_5517_1601# net6 0
C117 net6 VBP_CASC 0.06823f
C118 VOUT net3 0.33982f
C119 VSTRP_OUT VSTRP_IP 0.12024f
C120 a_16674_4519# a_14506_4519# 0
C121 a_14128_6329# a_14506_4519# 0.01317f
C122 VBN_CASC VINN 0.91049f
C123 VBP_CASC VINN 0.28345f
C124 a_13372_6329# a_12994_4519# 0.01317f
C125 a_9214_6199# a_9970_6199# 0.29626f
C126 VDD a_9214_6199# 0
C127 a_15904_6577# a_15596_6577# 0.00823f
C128 VOUT EN 0.00956f
C129 VINN net12 0.0026f
C130 a_9214_6199# EN_B 0.00135f
C131 net2 a_5801_1601# 0.00107f
C132 VDD a_16520_7509# 0.04529f
C133 net2 VBN_CASC 1.10729f
C134 a_16520_7509# EN_B 0.22583f
C135 VOUT a_5375_1601# 0
C136 VDD VSTRP_IP 4.91145f
C137 net2 VBP_CASC 0.56306f
C138 net2 a_5517_1601# 0.00107f
C139 net9 net3 0.122f
C140 a_5881_8265# VBP_CASC 0.00631f
C141 EN_B VSTRP_IP 0.12648f
C142 VINP a_5801_1601# 0
C143 VINP VBN_CASC 0.67615f
C144 MN_TAIL_BIAS VSTRP_IP 1.54162f
C145 net1 net5 2.49984f
C146 VDD VBN_CASC 1.70637f
C147 net2 net12 0.00715f
C148 a_13372_6329# VDD 0.01006f
C149 VBN_CASC EN_B 0.25548f
C150 a_13372_6329# EN_B 0.00649f
C151 a_9214_6199# a_8836_4519# 0.01451f
C152 VINP a_5517_1601# 0
C153 VINP VBP_CASC 0.17659f
C154 net3 net8 0
C155 VBN_CASC MN_TAIL_BIAS 0.00288f
C156 VDD VBP_CASC 3.75239f
C157 net14 net15 0.00438f
C158 net9 EN 1.23863f
C159 a_15442_4519# a_14506_4519# 0.00508f
C160 VINP net12 0
C161 VBP_CASC MN_TAIL_BIAS 0
C162 a_14506_4519# a_13750_4519# 0.29626f
C163 VDD net12 0.0342f
C164 a_11104_4519# a_10348_4519# 0.29626f
C165 a_8458_6199# VINN 0.00205f
C166 MN_TAIL_BIAS net12 18.8581f
C167 VOUT net6 0.0931f
C168 net8 EN 0.39767f
C169 VOUT VINN 0.69124f
C170 a_10726_6199# a_9970_6199# 0.29626f
C171 a_10726_6199# EN_B 0.00465f
C172 net4 net3 3.69367f
C173 a_8836_4519# net12 0.32707f
C174 a_10726_6199# MN_TAIL_BIAS 0.04823f
C175 a_13372_6329# a_12616_6329# 0.29626f
C176 a_15750_4519# a_15442_4519# 0.00823f
C177 VSTRP_OUT a_14128_6329# 0
C178 net9 net6 0
C179 VBP_CASC a_5739_8265# 0.0046f
C180 net7 a_9214_6199# 0.00663f
C181 net2 VOUT 3.27829f
C182 a_8458_6199# VDD 0.00777f
C183 a_16212_6577# a_16520_6577# 0.00823f
C184 VOUT a_5881_8265# 0
C185 a_8458_6199# EN_B 0
C186 net14 EN 0.12405f
C187 net4 EN 0.16096f
C188 net2 a_5659_1601# 0.00107f
C189 net6 net8 1.96582f
C190 a_16366_4519# VBP_TOP 0
C191 net9 VINN 0.35694f
C192 VINP VOUT 0.25941f
C193 net7 VSTRP_IP 0.00915f
C194 VOUT VDD 1.20267f
C195 VOUT EN_B 0
C196 VBP_TOP net15 0
C197 VINP a_5659_1601# 0
C198 VBN_CASC a_5091_1601# 0.00315f
C199 VBN_CASC net7 0.88994f
C200 VOUT MN_TAIL_BIAS 0.1093f
C201 net8 VINN 0.93096f
C202 VDD a_16674_4519# 0.05182f
C203 VDD a_14128_6329# 0.00879f
C204 a_8458_6199# a_8836_4519# 0.01451f
C205 net5 net3 2.27738f
C206 net7 VBP_CASC 0.27354f
C207 a_14128_6329# EN_B 0.00617f
C208 net2 net9 0.7148f
C209 a_16674_4519# MN_TAIL_BIAS 0
C210 net7 net12 0.40655f
C211 a_9592_4519# a_9970_6199# 0.01451f
C212 net1 net3 0.01214f
C213 VBP_TOP a_14506_4519# 0.00266f
C214 net2 net8 1.27439f
C215 VINP net9 0.12426f
C216 net4 net6 3.39501f
C217 net5 EN 0.47206f
C218 VDD net9 8.12339f
C219 a_9592_4519# MN_TAIL_BIAS 0.01297f
C220 VDD a_16520_6577# 0.05182f
C221 net9 EN_B 0.00264f
C222 a_16520_6577# EN_B 0
C223 net9 MN_TAIL_BIAS 0.00699f
C224 VINP net8 0.16448f
C225 a_10726_6199# a_10348_4519# 0.01451f
C226 a_12994_4519# a_13750_4519# 0.29626f
C227 VDD net8 2.11014f
C228 net4 VINN 2.89852f
C229 VOUT a_5739_8265# 0
C230 EN_B net8 0.08622f
C231 MN_TAIL_BIAS net8 0.00262f
C232 net14 VSTRP_OUT 0.8894f
C233 a_9592_4519# a_8836_4519# 0.29626f
C234 VBP_TOP EN 1.22319f
C235 a_16366_4519# a_14506_4519# 0
C236 VDD a_15442_4519# 0.05182f
C237 a_8458_6199# net7 0.04212f
C238 net2 net4 0.03057f
C239 a_15442_4519# MN_TAIL_BIAS 0
C240 VDD a_13750_4519# 0.01087f
C241 net4 a_5881_8265# 0
C242 a_14506_4519# net15 0.01323f
C243 a_15750_4519# VBP_TOP 0
C244 VDD a_15596_6577# 0.05182f
C245 a_16520_7509# VSTRP_IP 0.00142f
C246 a_15596_6577# EN_B 0
C247 VBN_CASC a_9214_6199# 0.00386f
C248 MN_TAIL_BIAS a_13750_4519# 0.01092f
C249 net6 net5 0.07806f
C250 VOUT a_5091_1601# 0
C251 a_11104_4519# a_10726_6199# 0.01451f
C252 VINP net4 0.75975f
C253 VOUT net7 2.92486f
C254 VDD net4 1.95179f
C255 net14 VDD 1.47514f
C256 net14 EN_B 0.11446f
C257 net5 VINN 0.22516f
C258 a_13372_6329# VSTRP_IP 0
C259 net1 net6 4.12887f
C260 VBN_CASC a_5801_1601# 0.00679f
C261 net15 EN 0.00135f
C262 VBP_TOP a_11860_6329# 0
C263 a_9592_4519# a_10348_4519# 0.29626f
C264 net1 VINN 3.88093f
C265 VBN_CASC a_5517_1601# 0.00408f
C266 VBN_CASC VBP_CASC 0.10706f
C267 a_9592_4519# net7 0
C268 net2 net5 0.27541f
C269 net7 net9 4.93703f
C270 VBP_CASC net12 0
C271 VSTRP_OUT VBP_TOP 0.00236f
C272 VINP net5 1.75037f
C273 net2 net1 7.57349f
C274 net7 net8 0.36743f
C275 net6 a_4949_1601# 0
C276 VDD net5 12.9652f
C277 a_12994_4519# VBP_TOP 0.00266f
C278 a_16212_6577# a_15904_6577# 0.00823f
C279 net4 a_5739_8265# 0
C280 a_5233_1601# net6 0
C281 a_8458_6199# a_9214_6199# 0.29626f
C282 a_15750_4519# a_14506_4519# 0
C283 net3 EN 0.21336f
C284 net2 VBP_TOP 0
C285 net1 VINP 12.3954f
C286 net1 VDD 4.34146f
C287 net1 MN_TAIL_BIAS 0
C288 VBP_TOP a_9970_6199# 0.15336f
C289 VDD VBP_TOP 7.37884f
C290 a_8458_6199# VBN_CASC 0.00515f
C291 VBP_TOP EN_B 0.18339f
C292 VBP_TOP MN_TAIL_BIAS 20.2384f
C293 net2 a_4949_1601# 0.00107f
C294 net7 net4 0
C295 VSTRP_OUT net15 0.05912f
C296 a_8458_6199# VBP_CASC 0
C297 net2 a_5233_1601# 0.00107f
C298 a_12238_4519# a_11860_6329# 0.01317f
C299 VOUT a_5801_1601# 0
C300 VOUT VBN_CASC 0.47969f
C301 a_8458_6199# net12 0.01488f
C302 VINP a_4949_1601# 0
C303 a_14128_6329# VSTRP_IP 0
C304 a_9592_4519# a_9214_6199# 0.01451f
C305 VDD a_15904_6577# 0.05182f
C306 net6 net3 3.46455f
C307 VOUT VBP_CASC 0.79285f
C308 VBN_CASC a_5659_1601# 0.00501f
C309 VINP a_5233_1601# 0
C310 a_15904_6577# EN_B 0
C311 VOUT a_5517_1601# 0
C312 VBP_TOP a_8836_4519# 0.01472f
C313 a_13372_6329# a_14128_6329# 0.29626f
C314 a_16366_4519# VDD 0.05182f
C315 VOUT net12 0.23962f
C316 a_16366_4519# MN_TAIL_BIAS 0
C317 a_12238_4519# a_12994_4519# 0.29626f
C318 net3 VINN 1.04464f
C319 VDD net15 0.46803f
C320 net9 VSTRP_IP 0.01073f
C321 a_16520_6577# VSTRP_IP 0.00154f
C322 EN_B net15 0.08633f
C323 a_16674_4519# net12 0
C324 a_16212_6577# EN 0
C325 MN_TAIL_BIAS net15 0.21057f
C326 VBN_CASC net9 6.04432f
C327 a_5375_1601# net6 0
C328 net7 net5 0.09176f
C329 VINN EN 0.07552f
C330 net9 VBP_CASC 3.42609f
C331 net2 net3 0.27651f
C332 a_9592_4519# net12 0.00494f
C333 a_5881_8265# net3 0
C334 VBN_CASC net8 0.11955f
C335 VSTRP_OUT EN 0.239f
C336 VDD a_12238_4519# 0.33635f
C337 VDD a_14506_4519# 0.06994f
C338 net9 net12 0
C339 net1 net7 11.9474f
C340 MN_TAIL_BIAS a_14506_4519# 0.01278f
C341 VBP_CASC net8 3.7608f
C342 a_12238_4519# MN_TAIL_BIAS 0.02518f
C343 VINP net3 2.76873f
C344 a_8458_6199# VOUT 0.00432f
C345 VDD net3 3.09758f
C346 VBP_TOP a_10348_4519# 0.06155f
C347 net8 net12 0.00141f
C348 a_15596_6577# VSTRP_IP 0.02222f
C349 net7 VBP_TOP 0.06186f
C350 VBP_TOP a_16058_4519# 0
C351 net14 a_16520_7509# 0.03632f
C352 net2 a_5375_1601# 0.00107f
C353 a_13372_6329# a_13750_4519# 0.01317f
C354 net14 VSTRP_IP 0.54919f
C355 VDD EN 4.84469f
C356 EN_B EN 0.76572f
C357 VINP a_5375_1601# 0
C358 VOUT a_5659_1601# 0
C359 VBN_CASC net4 0.93319f
C360 MN_TAIL_BIAS EN 0.40134f
C361 net6 VINN 3.10846f
C362 VDD a_15750_4519# 0.05182f
C363 net4 VBP_CASC 0.64592f
C364 a_12616_6329# a_12238_4519# 0.01317f
C365 a_15750_4519# MN_TAIL_BIAS 0
C366 a_11104_4519# VBP_TOP 0.00927f
C367 a_16366_4519# a_16058_4519# 0.00823f
C368 VINP GNDA 5.77369f
C369 VINN GNDA 8.13511f
C370 MN_TAIL_BIAS GNDA 24.8191f
C371 VOUT GNDA 1.52224f
C372 EN GNDA 0.95038f
C373 VDD GNDA 0.18951p
C374 a_5801_1601# GNDA 0.00199f
C375 a_5659_1601# GNDA 0.00208f
C376 a_5517_1601# GNDA 0.00222f
C377 a_5375_1601# GNDA 0.00246f
C378 a_5233_1601# GNDA 0.00291f
C379 a_5091_1601# GNDA 0.00378f
C380 a_4949_1601# GNDA 0.00549f
C381 a_16674_4519# GNDA 0.07013f
C382 a_16366_4519# GNDA 0.06378f
C383 a_16058_4519# GNDA 0.0636f
C384 a_15750_4519# GNDA 0.06348f
C385 a_15442_4519# GNDA 0.06586f
C386 a_16520_6577# GNDA 0.06569f
C387 a_16212_6577# GNDA 0.05209f
C388 a_15904_6577# GNDA 0.05112f
C389 a_15596_6577# GNDA 0.0508f
C390 a_14506_4519# GNDA 0.96236f
C391 a_14128_6329# GNDA 0.80034f
C392 a_13750_4519# GNDA 0.82955f
C393 a_13372_6329# GNDA 0.80034f
C394 a_12994_4519# GNDA 0.82955f
C395 a_12616_6329# GNDA 0.80042f
C396 a_12238_4519# GNDA 0.82955f
C397 a_11860_6329# GNDA 1.07698f
C398 a_11104_4519# GNDA 0.84074f
C399 a_10726_6199# GNDA 1.09969f
C400 a_10348_4519# GNDA 0.82624f
C401 a_9970_6199# GNDA 0.80315f
C402 a_9592_4519# GNDA 0.82624f
C403 a_9214_6199# GNDA 0.80311f
C404 a_8836_4519# GNDA 0.82624f
C405 net12 GNDA 14.881f
C406 net2 GNDA 4.81799f
C407 net1 GNDA 3.87945f
C408 a_8458_6199# GNDA 1.01319f
C409 a_16520_7509# GNDA 0.52047f
C410 net6 GNDA 2.90749f
C411 net15 GNDA 0.91319f
C412 VSTRP_OUT GNDA 0.16755f
C413 EN_B GNDA 5.36545f
C414 net14 GNDA 0.39288f
C415 VSTRP_IP GNDA 0.52382f
C416 net8 GNDA 10.941f
C417 VBP_CASC GNDA 0.56534f
C418 VBP_TOP GNDA 2.51209f
C419 VBN_CASC GNDA 5.19367f
C420 net4 GNDA 1.16403f
C421 net3 GNDA 1.23282f
C422 net9 GNDA 1.36019f
C423 net5 GNDA 3.2569f
.ends
