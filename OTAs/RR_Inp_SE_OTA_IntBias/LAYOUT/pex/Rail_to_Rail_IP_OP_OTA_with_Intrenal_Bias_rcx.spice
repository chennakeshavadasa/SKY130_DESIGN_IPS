* NGSPICE file created from Rail_to_Rail_IP_OP_OTA_with_Intrenal_Bias.ext - technology: sky130A

.subckt Rail_to_Rail_IP_OP_OTA_with_Intrenal_Bias VDD EN VINN VOUT VINP MN_TAIL_BIAS
+ GNDA
X0 net3.t5 VBP_CASC.t18 net5.t3 VDD.t46 sky130_fd_pr__pfet_01v8 ad=0.145 pd=1.58 as=0.0725 ps=0.79 w=0.5 l=0.5
X1 VSTRP_OUT.t1 EN_B.t5 VDD.t14 VDD.t13 sky130_fd_pr__pfet_01v8 ad=0.29 pd=2.58 as=0.5 ps=3 w=1 l=0.15
X2 net7.t14 VINN.t18 net2.t33 VDD.t70 sky130_fd_pr__pfet_01v8_lvt ad=0.58 pd=4.29 as=0.58 ps=4.29 w=4 l=2
X3 net2.t34 net8.t10 GNDA.t62 GNDA.t7 sky130_fd_pr__nfet_01v8 ad=0.0725 pd=0.79 as=0.0725 ps=0.79 w=0.5 l=2
X4 net3.t18 VINP.t30 net6.t21 GNDA.t55 sky130_fd_pr__nfet_01v8_lvt ad=0.3625 pd=2.79 as=0.3625 ps=2.79 w=2.5 l=2
X5 net7.t29 VINN.t3 net2.t28 VDD.t64 sky130_fd_pr__pfet_01v8_lvt ad=0.58 pd=4.29 as=0.58 ps=4.29 w=4 l=2
X6 VOUT.t3 VBP_CASC.t11 net4.t7 VDD.t30 sky130_fd_pr__pfet_01v8 ad=0.0725 pd=0.79 as=0.0725 ps=0.79 w=0.5 l=0.5
X7 VBP_TOP.t15 MN_TAIL_BIAS.t12 net12.t9 GNDA.t96 sky130_fd_pr__nfet_01v8 ad=1.45 pd=10.29 as=1.45 ps=10.29 w=10 l=4
X8 a_16520_7473.t1 EN.t0 GNDA.t85 GNDA.t84 sky130_fd_pr__nfet_01v8 ad=0.29 pd=2.58 as=0.5 ps=3 w=1 l=0.15
X9 net1.t10 VINP.t24 net7.t36 VDD.t71 sky130_fd_pr__pfet_01v8_lvt ad=0.58 pd=4.29 as=0.58 ps=4.29 w=4 l=2
X10 GNDA.t2 net8.t11 net1.t0 GNDA.t1 sky130_fd_pr__nfet_01v8 ad=0.0725 pd=0.79 as=0.0725 ps=0.79 w=0.5 l=2
X11 net6.t6 VINN.t33 net4.t12 GNDA.t56 sky130_fd_pr__nfet_01v8_lvt ad=0.3625 pd=2.79 as=0.3625 ps=2.79 w=2.5 l=2
X12 MN_TAIL_BIAS.t4 MN_TAIL_BIAS.t3 GNDA.t91 GNDA.t90 sky130_fd_pr__nfet_01v8 ad=1.45 pd=10.29 as=2.9 ps=20.58 w=10 l=4
X13 a_15904_6577.t0 VDD.t123 a_15750_4519.t0 GNDA.t67 sky130_fd_pr__nfet_01v8 ad=0.145 pd=1.58 as=0.145 ps=1.58 w=0.5 l=10
X14 GNDA.t100 net8.t26 net6.t23 GNDA.t15 sky130_fd_pr__nfet_01v8 ad=0.0725 pd=0.79 as=0.145 ps=1.58 w=0.5 l=2
X15 a_15596_6577.t1 VDD.t124 a_15750_4519.t1 GNDA.t66 sky130_fd_pr__nfet_01v8 ad=0.145 pd=1.58 as=0.145 ps=1.58 w=0.5 l=10
X16 VDD.t22 VBP_TOP.t21 VSTRP_IP.t2 VDD.t21 sky130_fd_pr__pfet_01v8 ad=0.29 pd=2.29 as=0.29 ps=2.29 w=2 l=2
X17 net2.t20 VINN.t27 net7.t5 VDD.t61 sky130_fd_pr__pfet_01v8_lvt ad=0.58 pd=4.29 as=0.58 ps=4.29 w=4 l=2
X18 VOUT.t10 VBN_CASC.t11 net2.t36 GNDA.t114 sky130_fd_pr__nfet_01v8 ad=0.145 pd=1.58 as=0.145 ps=1.58 w=0.5 l=0.5
X19 net1.t3 net8.t8 GNDA.t12 GNDA.t11 sky130_fd_pr__nfet_01v8 ad=0.145 pd=1.58 as=0.0725 ps=0.79 w=0.5 l=2
X20 EN_B.t1 EN.t2 VDD.t86 VDD.t85 sky130_fd_pr__pfet_01v8 ad=0.29 pd=2.58 as=0.5 ps=3 w=1 l=0.15
X21 VBP_TOP.t7 MN_TAIL_BIAS.t20 net12.t6 GNDA.t96 sky130_fd_pr__nfet_01v8 ad=1.45 pd=10.29 as=1.45 ps=10.29 w=10 l=4
X22 a_16212_6577.t1 VDD.t120 a_16366_4519.t0 GNDA.t70 sky130_fd_pr__nfet_01v8 ad=0.145 pd=1.58 as=0.145 ps=1.58 w=0.5 l=10
X23 VDD.t40 net9.t10 net7.t2 VDD.t39 sky130_fd_pr__pfet_01v8 ad=0.29 pd=2.29 as=0.29 ps=2.29 w=2 l=2
X24 net7.t10 VINN.t22 net2.t27 VDD.t66 sky130_fd_pr__pfet_01v8_lvt ad=0.58 pd=4.29 as=0.58 ps=4.29 w=4 l=2
X25 a_11860_6329.t1 VDD.t52 GNDA.t50 sky130_fd_pr__res_xhigh_po_1p41 l=7.05
X26 a_10726_6199.t1 a_10348_4519.t0 GNDA.t47 sky130_fd_pr__res_xhigh_po_1p41 l=6.4
X27 net4.t13 VINN.t32 net6.t8 GNDA.t57 sky130_fd_pr__nfet_01v8_lvt ad=0.725 pd=5.58 as=0.3625 ps=2.79 w=2.5 l=2
X28 VDD.t36 VBP_TOP.t19 VSTRP_IP.t4 VDD.t35 sky130_fd_pr__pfet_01v8 ad=0.58 pd=4.58 as=0.29 ps=2.29 w=2 l=2
X29 EN_B.t0 EN.t1 GNDA.t83 GNDA.t82 sky130_fd_pr__nfet_01v8 ad=0.29 pd=2.58 as=0.5 ps=3 w=1 l=0.15
X30 net1.t36 net8.t12 GNDA.t113 GNDA.t30 sky130_fd_pr__nfet_01v8 ad=0.0725 pd=0.79 as=0.0725 ps=0.79 w=0.5 l=2
X31 VBP_TOP.t3 MN_TAIL_BIAS.t24 net12.t2 GNDA.t88 sky130_fd_pr__nfet_01v8 ad=1.45 pd=10.29 as=1.45 ps=10.29 w=10 l=4
X32 VDD.t56 net5.t15 net3.t11 VDD.t55 sky130_fd_pr__pfet_01v8 ad=0.29 pd=2.29 as=0.29 ps=2.29 w=2 l=2
X33 net2.t30 VINN.t17 net7.t15 VDD.t71 sky130_fd_pr__pfet_01v8_lvt ad=0.58 pd=4.29 as=0.58 ps=4.29 w=4 l=2
X34 VBP_TOP.t9 MN_TAIL_BIAS.t18 net12.t12 GNDA.t86 sky130_fd_pr__nfet_01v8 ad=1.45 pd=10.29 as=2.9 ps=20.58 w=10 l=4
X35 VOUT.t6 VBP_CASC.t17 net4.t1 VDD.t58 sky130_fd_pr__pfet_01v8 ad=0.0725 pd=0.79 as=0.145 ps=1.58 w=0.5 l=0.5
X36 net1.t21 VINP.t11 net7.t49 VDD.t63 sky130_fd_pr__pfet_01v8_lvt ad=0.58 pd=4.29 as=0.58 ps=4.29 w=4 l=2
X37 net2.t19 VINN.t21 net7.t11 VDD.t67 sky130_fd_pr__pfet_01v8_lvt ad=1.16 pd=8.58 as=0.58 ps=4.29 w=4 l=2
X38 net5.t2 VBP_CASC.t19 net3.t6 VDD.t108 sky130_fd_pr__pfet_01v8 ad=0.0725 pd=0.79 as=0.0725 ps=0.79 w=0.5 l=0.5
X39 MN_TAIL_BIAS.t2 EN_B.t2 GNDA.t29 GNDA.t28 sky130_fd_pr__nfet_01v8 ad=0.145 pd=1.58 as=0.145 ps=1.58 w=0.5 l=6.4
X40 net4.t18 net5.t22 VDD.t79 VDD.t78 sky130_fd_pr__pfet_01v8 ad=0.29 pd=2.29 as=0.29 ps=2.29 w=2 l=2
X41 net1.t17 VINP.t20 net7.t40 VDD.t61 sky130_fd_pr__pfet_01v8_lvt ad=0.58 pd=4.29 as=0.58 ps=4.29 w=4 l=2
X42 GNDA.t76 net8.t0 net8.t1 GNDA.t39 sky130_fd_pr__nfet_01v8 ad=0.0725 pd=0.79 as=0.145 ps=1.58 w=0.5 l=2
X43 net6.t4 net8.t17 GNDA.t25 GNDA.t24 sky130_fd_pr__nfet_01v8 ad=0.145 pd=1.58 as=0.0725 ps=0.79 w=0.5 l=2
X44 net12.t14 MN_TAIL_BIAS.t19 VBP_TOP.t8 GNDA.t97 sky130_fd_pr__nfet_01v8 ad=2.9 pd=20.58 as=1.45 ps=10.29 w=10 l=4
X45 GNDA.t22 net8.t13 net2.t3 GNDA.t21 sky130_fd_pr__nfet_01v8 ad=0.0725 pd=0.79 as=0.145 ps=1.58 w=0.5 l=2
X46 a_5517_1601.t1 VBN_CASC.t6 a_5375_1601.t1 GNDA.t51 sky130_fd_pr__nfet_01v8 ad=0.0525 pd=0.71 as=0.0525 ps=0.71 w=0.5 l=0.5
X47 net8.t4 VBP_TOP.t27 VDD.t112 VDD.t111 sky130_fd_pr__pfet_01v8 ad=0.58 pd=4.58 as=0.29 ps=2.29 w=2 l=2
X48 VDD.t90 net9.t5 net7.t61 VDD.t89 sky130_fd_pr__pfet_01v8 ad=0.29 pd=2.29 as=0.29 ps=2.29 w=2 l=2
X49 net7.t45 VINP.t15 net1.t14 VDD.t66 sky130_fd_pr__pfet_01v8_lvt ad=0.58 pd=4.29 as=0.58 ps=4.29 w=4 l=2
X50 net7.t23 VINN.t9 net2.t31 VDD.t72 sky130_fd_pr__pfet_01v8_lvt ad=0.58 pd=4.29 as=0.58 ps=4.29 w=4 l=2
X51 a_5091_1601.t1 VBN_CASC.t9 a_4949_1601.t1 GNDA.t101 sky130_fd_pr__nfet_01v8 ad=0.0525 pd=0.71 as=0.0525 ps=0.71 w=0.5 l=0.5
X52 net15.t1 a_14506_4519.t0 GNDA.t38 sky130_fd_pr__res_xhigh_po_1p41 l=7.05
X53 net12.t1 MN_TAIL_BIAS.t21 VBP_TOP.t6 GNDA.t95 sky130_fd_pr__nfet_01v8 ad=1.45 pd=10.29 as=1.45 ps=10.29 w=10 l=4
X54 net4.t8 VBP_CASC.t10 VOUT.t9 VDD.t110 sky130_fd_pr__pfet_01v8 ad=0.145 pd=1.58 as=0.0725 ps=0.79 w=0.5 l=0.5
X55 net6.t2 net8.t14 GNDA.t20 GNDA.t19 sky130_fd_pr__nfet_01v8 ad=0.145 pd=1.58 as=0.0725 ps=0.79 w=0.5 l=2
X56 net12.t10 MN_TAIL_BIAS.t23 VBP_TOP.t4 GNDA.t89 sky130_fd_pr__nfet_01v8 ad=2.9 pd=20.58 as=1.45 ps=10.29 w=10 l=4
X57 a_5659_1601.t1 VBN_CASC.t5 a_5517_1601.t0 GNDA.t14 sky130_fd_pr__nfet_01v8 ad=0.0525 pd=0.71 as=0.0525 ps=0.71 w=0.5 l=0.5
X58 VDD.t49 net5.t21 net4.t9 VDD.t48 sky130_fd_pr__pfet_01v8 ad=0.29 pd=2.29 as=0.29 ps=2.29 w=2 l=2
X59 VBP_TOP.t0 EN.t3 VDD.t81 VDD.t80 sky130_fd_pr__pfet_01v8 ad=0.145 pd=1.58 as=0.145 ps=1.58 w=0.5 l=1
X60 net6.t5 VINN.t30 net4.t15 GNDA.t59 sky130_fd_pr__nfet_01v8_lvt ad=0.3625 pd=2.79 as=0.3625 ps=2.79 w=2.5 l=2
X61 net2.t6 VINN.t4 net7.t28 VDD.t63 sky130_fd_pr__pfet_01v8_lvt ad=0.58 pd=4.29 as=0.58 ps=4.29 w=4 l=2
X62 net7.t4 net9.t11 VDD.t51 VDD.t50 sky130_fd_pr__pfet_01v8 ad=0.29 pd=2.29 as=0.29 ps=2.29 w=2 l=2
X63 VBN_CASC.t3 EN_B.t3 GNDA.t109 GNDA.t108 sky130_fd_pr__nfet_01v8 ad=0.29 pd=2.58 as=0.145 ps=1.29 w=1 l=2
X64 net2.t25 VINN.t23 net7.t9 VDD.t65 sky130_fd_pr__pfet_01v8_lvt ad=0.58 pd=4.29 as=0.58 ps=4.29 w=4 l=2
X65 net6.t17 VINP.t32 net3.t16 GNDA.t61 sky130_fd_pr__nfet_01v8_lvt ad=0.3625 pd=2.79 as=0.3625 ps=2.79 w=2.5 l=2
X66 net1.t22 VINP.t14 net7.t46 VDD.t67 sky130_fd_pr__pfet_01v8_lvt ad=1.16 pd=8.58 as=0.58 ps=4.29 w=4 l=2
X67 GNDA.t4 net8.t18 net6.t0 GNDA.t3 sky130_fd_pr__nfet_01v8 ad=0.0725 pd=0.79 as=0.145 ps=1.58 w=0.5 l=2
X68 GNDA.t112 EN_B.t4 net8.t3 GNDA.t111 sky130_fd_pr__nfet_01v8 ad=0.145 pd=1.29 as=0.29 ps=2.58 w=1 l=1
X69 net2.t26 VINN.t8 net7.t24 VDD.t73 sky130_fd_pr__pfet_01v8_lvt ad=0.58 pd=4.29 as=0.58 ps=4.29 w=4 l=2
X70 MN_TAIL_BIAS.t6 MN_TAIL_BIAS.t5 GNDA.t98 GNDA.t90 sky130_fd_pr__nfet_01v8 ad=1.45 pd=10.29 as=2.9 ps=20.58 w=10 l=4
X71 net3.t1 net5.t12 VDD.t9 VDD.t8 sky130_fd_pr__pfet_01v8 ad=0.58 pd=4.58 as=0.29 ps=2.29 w=2 l=2
X72 VSTRP_IP.t5 VBP_TOP.t20 VDD.t44 VDD.t43 sky130_fd_pr__pfet_01v8 ad=0.29 pd=2.29 as=0.29 ps=2.29 w=2 l=2
X73 net12.t11 MN_TAIL_BIAS.t13 VBP_TOP.t14 GNDA.t95 sky130_fd_pr__nfet_01v8 ad=1.45 pd=10.29 as=1.45 ps=10.29 w=10 l=4
X74 net7.t6 VINN.t26 net2.t12 VDD.t62 sky130_fd_pr__pfet_01v8_lvt ad=0.58 pd=4.29 as=0.58 ps=4.29 w=4 l=2
X75 GNDA.t99 MN_TAIL_BIAS.t9 MN_TAIL_BIAS.t10 GNDA.t92 sky130_fd_pr__nfet_01v8 ad=2.9 pd=20.58 as=1.45 ps=10.29 w=10 l=4
X76 VBP_TOP.t11 MN_TAIL_BIAS.t16 net12.t7 GNDA.t88 sky130_fd_pr__nfet_01v8 ad=1.45 pd=10.29 as=1.45 ps=10.29 w=10 l=4
X77 a_5801_1601.t0 VBN_CASC.t4 a_5659_1601.t0 GNDA.t5 sky130_fd_pr__nfet_01v8 ad=0.0525 pd=0.71 as=0.0525 ps=0.71 w=0.5 l=0.5
X78 GNDA.t93 MN_TAIL_BIAS.t7 MN_TAIL_BIAS.t8 GNDA.t92 sky130_fd_pr__nfet_01v8 ad=2.9 pd=20.58 as=1.45 ps=10.29 w=10 l=4
X79 net7.t21 VINN.t11 net2.t8 VDD.t70 sky130_fd_pr__pfet_01v8_lvt ad=0.58 pd=4.29 as=0.58 ps=4.29 w=4 l=2
X80 net4.t16 VINN.t29 net6.t12 GNDA.t60 sky130_fd_pr__nfet_01v8_lvt ad=0.3625 pd=2.79 as=0.3625 ps=2.79 w=2.5 l=2
X81 a_11860_6329.t0 a_12238_4519.t0 GNDA.t35 sky130_fd_pr__res_xhigh_po_1p41 l=7.05
X82 net7.t58 VINP.t2 net1.t13 VDD.t72 sky130_fd_pr__pfet_01v8_lvt ad=0.58 pd=4.29 as=0.58 ps=4.29 w=4 l=2
X83 net4.t20 net5.t18 VDD.t114 VDD.t113 sky130_fd_pr__pfet_01v8 ad=0.29 pd=2.29 as=0.29 ps=2.29 w=2 l=2
X84 a_13372_6329.t1 a_12994_4519.t1 GNDA.t102 sky130_fd_pr__res_xhigh_po_1p41 l=7.05
X85 VBP_TOP.t1 MN_TAIL_BIAS.t26 net12.t5 GNDA.t86 sky130_fd_pr__nfet_01v8 ad=1.45 pd=10.29 as=2.9 ps=20.58 w=10 l=4
X86 VBN_CASC.t2 VBN_CASC.t1 a_5801_1601.t1 GNDA.t77 sky130_fd_pr__nfet_01v8 ad=0.145 pd=1.58 as=0.0525 ps=0.71 w=0.5 l=0.5
X87 a_5233_1601.t1 VBN_CASC.t8 a_5091_1601.t0 GNDA.t80 sky130_fd_pr__nfet_01v8 ad=0.0525 pd=0.71 as=0.0525 ps=0.71 w=0.5 l=0.5
X88 a_16520_6577.t0 VDD.t119 a_16366_4519.t1 GNDA.t71 sky130_fd_pr__nfet_01v8 ad=0.145 pd=1.58 as=0.145 ps=1.58 w=0.5 l=10
X89 net7.t33 VINP.t27 net1.t27 VDD.t68 sky130_fd_pr__pfet_01v8_lvt ad=0.58 pd=4.29 as=1.16 ps=8.58 w=4 l=2
X90 net4.t2 VBP_CASC.t16 VOUT.t5 VDD.t57 sky130_fd_pr__pfet_01v8 ad=0.0725 pd=0.79 as=0.0725 ps=0.79 w=0.5 l=0.5
X91 VBP_TOP.t5 MN_TAIL_BIAS.t22 net12.t4 GNDA.t94 sky130_fd_pr__nfet_01v8 ad=1.45 pd=10.29 as=2.9 ps=20.58 w=10 l=4
X92 net1.t25 VINP.t16 net7.t44 VDD.t65 sky130_fd_pr__pfet_01v8_lvt ad=0.58 pd=4.29 as=0.58 ps=4.29 w=4 l=2
X93 net1.t28 VINP.t26 net7.t34 VDD.t69 sky130_fd_pr__pfet_01v8_lvt ad=0.58 pd=4.29 as=0.58 ps=4.29 w=4 l=2
X94 GNDA.t32 net8.t20 net1.t4 GNDA.t26 sky130_fd_pr__nfet_01v8 ad=0.0725 pd=0.79 as=0.0725 ps=0.79 w=0.5 l=2
X95 VBN_CASC.t0 net9.t8 VDD.t1 VDD.t0 sky130_fd_pr__pfet_01v8 ad=0.58 pd=4.58 as=0.29 ps=2.29 w=2 l=2
X96 net5.t4 VBP_CASC.t9 net3.t2 VDD.t97 sky130_fd_pr__pfet_01v8 ad=0.0725 pd=0.79 as=0.145 ps=1.58 w=0.5 l=0.5
X97 VSTRP_IP.t7 VBP_TOP.t24 VDD.t107 VDD.t106 sky130_fd_pr__pfet_01v8 ad=0.29 pd=2.29 as=0.29 ps=2.29 w=2 l=2
X98 net6.t9 VINN.t35 net4.t10 GNDA.t54 sky130_fd_pr__nfet_01v8_lvt ad=0.3625 pd=2.79 as=0.725 ps=5.58 w=2.5 l=2
X99 net1.t20 VINP.t1 net7.t59 VDD.t73 sky130_fd_pr__pfet_01v8_lvt ad=0.58 pd=4.29 as=0.58 ps=4.29 w=4 l=2
X100 a_5375_1601.t0 VBN_CASC.t7 a_5233_1601.t0 GNDA.t6 sky130_fd_pr__nfet_01v8 ad=0.0525 pd=0.71 as=0.0525 ps=0.71 w=0.5 l=0.5
X101 a_9214_6199.t1 a_8836_4519.t1 GNDA.t43 sky130_fd_pr__res_xhigh_po_1p41 l=6.4
X102 net7.t39 VINP.t21 net1.t34 VDD.t74 sky130_fd_pr__pfet_01v8_lvt ad=0.58 pd=4.29 as=0.58 ps=4.29 w=4 l=2
X103 net7.t41 VINP.t19 net1.t33 VDD.t62 sky130_fd_pr__pfet_01v8_lvt ad=0.58 pd=4.29 as=0.58 ps=4.29 w=4 l=2
X104 net4.t14 VINN.t31 net6.t7 GNDA.t58 sky130_fd_pr__nfet_01v8_lvt ad=0.3625 pd=2.79 as=0.3625 ps=2.79 w=2.5 l=2
X105 net7.t56 VINP.t4 net1.t26 VDD.t70 sky130_fd_pr__pfet_01v8_lvt ad=0.58 pd=4.29 as=0.58 ps=4.29 w=4 l=2
X106 net5.t6 VBP_CASC.t7 net3.t7 VDD.t32 sky130_fd_pr__pfet_01v8 ad=0.0725 pd=0.79 as=0.0725 ps=0.79 w=0.5 l=0.5
X107 net7.t8 VINN.t24 net2.t23 VDD.t64 sky130_fd_pr__pfet_01v8_lvt ad=0.58 pd=4.29 as=0.58 ps=4.29 w=4 l=2
X108 net12.t3 MN_TAIL_BIAS.t25 VBP_TOP.t2 GNDA.t87 sky130_fd_pr__nfet_01v8 ad=1.45 pd=10.29 as=1.45 ps=10.29 w=10 l=4
X109 net9.t3 EN.t6 VDD.t84 VDD.t83 sky130_fd_pr__pfet_01v8 ad=0.58 pd=4.58 as=0.58 ps=4.58 w=2 l=2
X110 VDD.t99 VBP_TOP.t28 net8.t2 VDD.t98 sky130_fd_pr__pfet_01v8 ad=0.29 pd=2.29 as=0.58 ps=4.58 w=2 l=2
X111 net4.t11 VINN.t34 net6.t10 GNDA.t55 sky130_fd_pr__nfet_01v8_lvt ad=0.3625 pd=2.79 as=0.3625 ps=2.79 w=2.5 l=2
X112 net7.t12 VINN.t20 net2.t21 VDD.t68 sky130_fd_pr__pfet_01v8_lvt ad=0.58 pd=4.29 as=1.16 ps=8.58 w=4 l=2
X113 net2.t32 VINN.t10 net7.t22 VDD.t71 sky130_fd_pr__pfet_01v8_lvt ad=0.58 pd=4.29 as=0.58 ps=4.29 w=4 l=2
X114 a_13372_6329.t0 a_13750_4519.t0 GNDA.t78 sky130_fd_pr__res_xhigh_po_1p41 l=7.05
X115 a_12616_6329.t1 a_12238_4519.t1 GNDA.t49 sky130_fd_pr__res_xhigh_po_1p41 l=7.05
X116 net1.t1 net8.t21 GNDA.t8 GNDA.t7 sky130_fd_pr__nfet_01v8 ad=0.0725 pd=0.79 as=0.0725 ps=0.79 w=0.5 l=2
X117 VDD.t27 VBP_TOP.t23 VSTRP_IP.t3 VDD.t26 sky130_fd_pr__pfet_01v8 ad=0.29 pd=2.29 as=0.29 ps=2.29 w=2 l=2
X118 net12.t8 MN_TAIL_BIAS.t11 VBP_TOP.t16 GNDA.t97 sky130_fd_pr__nfet_01v8 ad=2.9 pd=20.58 as=1.45 ps=10.29 w=10 l=4
X119 a_5739_8229.t0 VBP_CASC.t5 VDD.t96 VDD.t95 sky130_fd_pr__pfet_01v8 ad=0.0525 pd=0.71 as=0.145 ps=1.58 w=0.5 l=0.5
X120 net2.t7 VINN.t19 net7.t13 VDD.t69 sky130_fd_pr__pfet_01v8_lvt ad=0.58 pd=4.29 as=0.58 ps=4.29 w=4 l=2
X121 net1.t18 VINP.t13 net7.t47 VDD.t61 sky130_fd_pr__pfet_01v8_lvt ad=0.58 pd=4.29 as=0.58 ps=4.29 w=4 l=2
X122 GNDA.t9 net8.t22 net2.t0 GNDA.t1 sky130_fd_pr__nfet_01v8 ad=0.0725 pd=0.79 as=0.0725 ps=0.79 w=0.5 l=2
X123 VDD.t24 net9.t12 net7.t0 VDD.t23 sky130_fd_pr__pfet_01v8 ad=0.29 pd=2.29 as=0.58 ps=4.58 w=2 l=2
X124 net7.t18 VINN.t14 net2.t18 VDD.t74 sky130_fd_pr__pfet_01v8_lvt ad=0.58 pd=4.29 as=0.58 ps=4.29 w=4 l=2
X125 net1.t2 VBN_CASC.t16 net5.t8 GNDA.t10 sky130_fd_pr__nfet_01v8 ad=0.145 pd=1.58 as=0.145 ps=1.58 w=0.5 l=0.5
X126 MN_TAIL_BIAS.t1 VSTRP_OUT.t3 net15.t0 VDD.t45 sky130_fd_pr__pfet_01v8 ad=0.145 pd=1.58 as=0.145 ps=1.58 w=0.5 l=4
X127 net7.t52 VINP.t8 net1.t9 VDD.t66 sky130_fd_pr__pfet_01v8_lvt ad=0.58 pd=4.29 as=0.58 ps=4.29 w=4 l=2
X128 net2.t35 net8.t19 GNDA.t107 GNDA.t11 sky130_fd_pr__nfet_01v8 ad=0.145 pd=1.58 as=0.0725 ps=0.79 w=0.5 l=2
X129 VOUT.t4 VBP_CASC.t13 net4.t5 VDD.t47 sky130_fd_pr__pfet_01v8 ad=0.0725 pd=0.79 as=0.145 ps=1.58 w=0.5 l=0.5
X130 net7.t43 VINP.t17 net1.t30 VDD.t64 sky130_fd_pr__pfet_01v8_lvt ad=0.58 pd=4.29 as=0.58 ps=4.29 w=4 l=2
X131 VBP_TOP.t13 MN_TAIL_BIAS.t14 net12.t13 GNDA.t94 sky130_fd_pr__nfet_01v8 ad=1.45 pd=10.29 as=2.9 ps=20.58 w=10 l=4
X132 GNDA.t16 net8.t15 net6.t1 GNDA.t15 sky130_fd_pr__nfet_01v8 ad=0.0725 pd=0.79 as=0.145 ps=1.58 w=0.5 l=2
X133 VSTRP_IP.t6 VDD.t126 a_15442_4519.t0 GNDA.t64 sky130_fd_pr__nfet_01v8 ad=0.145 pd=1.58 as=0.145 ps=1.58 w=0.5 l=10
X134 GNDA.t74 VDD.t117 a_16674_4519.t1 GNDA.t73 sky130_fd_pr__nfet_01v8 ad=0.145 pd=1.58 as=0.145 ps=1.58 w=0.5 l=10
X135 net6.t20 VINP.t29 net3.t19 GNDA.t56 sky130_fd_pr__nfet_01v8_lvt ad=0.3625 pd=2.79 as=0.3625 ps=2.79 w=2.5 l=2
X136 a_16520_6577.t1 VDD.t118 a_16674_4519.t0 GNDA.t72 sky130_fd_pr__nfet_01v8 ad=0.145 pd=1.58 as=0.145 ps=1.58 w=0.5 l=10
X137 a_10726_6199.t0 a_11104_4519.t1 GNDA.t46 sky130_fd_pr__res_xhigh_po_1p41 l=6.4
X138 net1.t23 VINP.t3 net7.t57 VDD.t71 sky130_fd_pr__pfet_01v8_lvt ad=0.58 pd=4.29 as=0.58 ps=4.29 w=4 l=2
X139 VDD.t101 net5.t19 net3.t21 VDD.t100 sky130_fd_pr__pfet_01v8 ad=0.29 pd=2.29 as=0.29 ps=2.29 w=2 l=2
X140 VOUT.t7 VBP_CASC.t15 net4.t3 VDD.t77 sky130_fd_pr__pfet_01v8 ad=0.0725 pd=0.79 as=0.0725 ps=0.79 w=0.5 l=0.5
X141 net7.t3 net9.t9 VDD.t42 VDD.t41 sky130_fd_pr__pfet_01v8 ad=0.58 pd=4.58 as=0.29 ps=2.29 w=2 l=2
X142 VBP_CASC.t2 VBP_CASC.t1 a_5881_8229.t0 VDD.t10 sky130_fd_pr__pfet_01v8 ad=0.145 pd=1.58 as=0.0525 ps=0.71 w=0.5 l=0.5
X143 net1.t8 VINP.t7 net7.t53 VDD.t67 sky130_fd_pr__pfet_01v8_lvt ad=1.16 pd=8.58 as=0.58 ps=4.29 w=4 l=2
X144 net12.t16 MN_TAIL_BIAS.t17 VBP_TOP.t10 GNDA.t87 sky130_fd_pr__nfet_01v8 ad=1.45 pd=10.29 as=1.45 ps=10.29 w=10 l=4
X145 net2.t5 net8.t23 GNDA.t31 GNDA.t30 sky130_fd_pr__nfet_01v8 ad=0.0725 pd=0.79 as=0.0725 ps=0.79 w=0.5 l=2
X146 a_15904_6577.t1 VDD.t122 a_16058_4519.t1 GNDA.t68 sky130_fd_pr__nfet_01v8 ad=0.145 pd=1.58 as=0.145 ps=1.58 w=0.5 l=10
X147 net2.t11 VINN.t6 net7.t26 VDD.t61 sky130_fd_pr__pfet_01v8_lvt ad=0.58 pd=4.29 as=0.58 ps=4.29 w=4 l=2
X148 net7.t62 net9.t6 VDD.t92 VDD.t91 sky130_fd_pr__pfet_01v8 ad=0.29 pd=2.29 as=0.29 ps=2.29 w=2 l=2
X149 net3.t0 net5.t16 VDD.t5 VDD.t4 sky130_fd_pr__pfet_01v8 ad=0.29 pd=2.29 as=0.29 ps=2.29 w=2 l=2
X150 net3.t4 VBP_CASC.t6 net5.t7 VDD.t31 sky130_fd_pr__pfet_01v8 ad=0.145 pd=1.58 as=0.0725 ps=0.79 w=0.5 l=0.5
X151 net3.t20 VINP.t28 net6.t18 GNDA.t57 sky130_fd_pr__nfet_01v8_lvt ad=0.725 pd=5.58 as=0.3625 ps=2.79 w=2.5 l=2
X152 net7.t31 VINN.t1 net2.t22 VDD.t66 sky130_fd_pr__pfet_01v8_lvt ad=0.58 pd=4.29 as=0.58 ps=4.29 w=4 l=2
X153 MN_TAIL_BIAS.t0 VBP_TOP.t26 VDD.t34 VDD.t33 sky130_fd_pr__pfet_01v8 ad=0.58 pd=4.58 as=0.29 ps=2.29 w=2 l=2
X154 net14.t0 VSTRP_IP.t9 VDD.t54 VDD.t53 sky130_fd_pr__pfet_01v8 ad=0.29 pd=2.58 as=0.5 ps=3 w=1 l=0.15
X155 net5.t9 VBN_CASC.t13 net1.t5 GNDA.t41 sky130_fd_pr__nfet_01v8 ad=0.0725 pd=0.79 as=0.145 ps=1.58 w=0.5 l=0.5
X156 GNDA.t110 net8.t24 net1.t35 GNDA.t21 sky130_fd_pr__nfet_01v8 ad=0.0725 pd=0.79 as=0.145 ps=1.58 w=0.5 l=2
X157 a_14128_6329.t1 a_13750_4519.t1 GNDA.t104 sky130_fd_pr__res_xhigh_po_1p41 l=7.05
X158 net2.t1 VBN_CASC.t15 VOUT.t1 GNDA.t13 sky130_fd_pr__nfet_01v8 ad=0.0725 pd=0.79 as=0.145 ps=1.58 w=0.5 l=0.5
X159 net14.t1 VSTRP_IP.t8 GNDA.t106 GNDA.t105 sky130_fd_pr__nfet_01v8 ad=0.29 pd=2.58 as=0.5 ps=3 w=1 l=0.15
X160 net1.t24 VINP.t9 net7.t51 VDD.t65 sky130_fd_pr__pfet_01v8_lvt ad=0.58 pd=4.29 as=0.58 ps=4.29 w=4 l=2
X161 GNDA.t40 net8.t5 VBP_CASC.t0 GNDA.t39 sky130_fd_pr__nfet_01v8 ad=0.145 pd=1.58 as=0.145 ps=1.58 w=0.5 l=2
X162 net6.t14 net8.t6 GNDA.t79 GNDA.t24 sky130_fd_pr__nfet_01v8 ad=0.145 pd=1.58 as=0.0725 ps=0.79 w=0.5 l=2
X163 net2.t16 VINN.t25 net7.t7 VDD.t63 sky130_fd_pr__pfet_01v8_lvt ad=0.58 pd=4.29 as=0.58 ps=4.29 w=4 l=2
X164 net6.t13 net8.t25 GNDA.t75 GNDA.t19 sky130_fd_pr__nfet_01v8 ad=0.145 pd=1.58 as=0.0725 ps=0.79 w=0.5 l=2
X165 net2.t29 VINN.t0 net7.t32 VDD.t67 sky130_fd_pr__pfet_01v8_lvt ad=1.16 pd=8.58 as=0.58 ps=4.29 w=4 l=2
X166 VDD.t116 net5.t13 net4.t21 VDD.t115 sky130_fd_pr__pfet_01v8 ad=0.29 pd=2.29 as=0.29 ps=2.29 w=2 l=2
X167 net5.t0 VBP_CASC.t21 net3.t8 VDD.t93 sky130_fd_pr__pfet_01v8 ad=0.0725 pd=0.79 as=0.145 ps=1.58 w=0.5 l=0.5
X168 net6.t16 VINP.t34 net3.t14 GNDA.t59 sky130_fd_pr__nfet_01v8_lvt ad=0.3625 pd=2.79 as=0.3625 ps=2.79 w=2.5 l=2
X169 net7.t48 VINP.t12 net1.t7 VDD.t62 sky130_fd_pr__pfet_01v8_lvt ad=0.58 pd=4.29 as=0.58 ps=4.29 w=4 l=2
X170 net3.t10 net5.t20 VDD.t12 VDD.t11 sky130_fd_pr__pfet_01v8 ad=0.29 pd=2.29 as=0.29 ps=2.29 w=2 l=2
X171 net12.t15 MN_TAIL_BIAS.t15 VBP_TOP.t12 GNDA.t89 sky130_fd_pr__nfet_01v8 ad=2.9 pd=20.58 as=1.45 ps=10.29 w=10 l=4
X172 net7.t37 VINP.t23 net1.t12 VDD.t72 sky130_fd_pr__pfet_01v8_lvt ad=0.58 pd=4.29 as=0.58 ps=4.29 w=4 l=2
X173 net3.t15 VINP.t33 net6.t15 GNDA.t60 sky130_fd_pr__nfet_01v8_lvt ad=0.3625 pd=2.79 as=0.3625 ps=2.79 w=2.5 l=2
X174 net4.t6 VBP_CASC.t12 VOUT.t8 VDD.t94 sky130_fd_pr__pfet_01v8 ad=0.0725 pd=0.79 as=0.0725 ps=0.79 w=0.5 l=0.5
X175 net7.t19 VINN.t13 net2.t15 VDD.t68 sky130_fd_pr__pfet_01v8_lvt ad=0.58 pd=4.29 as=1.16 ps=8.58 w=4 l=2
X176 GNDA.t23 net8.t7 net6.t3 GNDA.t3 sky130_fd_pr__nfet_01v8 ad=0.0725 pd=0.79 as=0.145 ps=1.58 w=0.5 l=2
X177 a_8458_6199.t0 net12.t0 GNDA.t0 sky130_fd_pr__res_xhigh_po_1p41 l=6.4
X178 a_5881_8229.t1 VBP_CASC.t4 a_5739_8229.t1 VDD.t109 sky130_fd_pr__pfet_01v8 ad=0.0525 pd=0.71 as=0.0525 ps=0.71 w=0.5 l=0.5
X179 a_9214_6199.t0 a_9592_4519.t1 GNDA.t42 sky130_fd_pr__res_xhigh_po_1p41 l=6.4
X180 net4.t4 VBP_CASC.t14 VOUT.t0 VDD.t15 sky130_fd_pr__pfet_01v8 ad=0.145 pd=1.58 as=0.0725 ps=0.79 w=0.5 l=0.5
X181 a_15596_6577.t0 VDD.t125 a_15442_4519.t1 GNDA.t65 sky130_fd_pr__nfet_01v8 ad=0.145 pd=1.58 as=0.145 ps=1.58 w=0.5 l=10
X182 net6.t11 VINN.t28 net4.t17 GNDA.t61 sky130_fd_pr__nfet_01v8_lvt ad=0.3625 pd=2.79 as=0.3625 ps=2.79 w=2.5 l=2
X183 net2.t13 VINN.t2 net7.t30 VDD.t65 sky130_fd_pr__pfet_01v8_lvt ad=0.58 pd=4.29 as=0.58 ps=4.29 w=4 l=2
X184 VDD.t88 EN.t5 VBP_CASC.t3 VDD.t87 sky130_fd_pr__pfet_01v8 ad=0.58 pd=4.58 as=0.58 ps=4.58 w=2 l=2
X185 net1.t31 VINP.t18 net7.t42 VDD.t63 sky130_fd_pr__pfet_01v8_lvt ad=0.58 pd=4.29 as=0.58 ps=4.29 w=4 l=2
X186 net2.t10 VINN.t12 net7.t20 VDD.t69 sky130_fd_pr__pfet_01v8_lvt ad=0.58 pd=4.29 as=0.58 ps=4.29 w=4 l=2
X187 a_14128_6329.t0 a_14506_4519.t1 GNDA.t103 sky130_fd_pr__res_xhigh_po_1p41 l=7.05
X188 net1.t11 VINP.t22 net7.t38 VDD.t73 sky130_fd_pr__pfet_01v8_lvt ad=0.58 pd=4.29 as=0.58 ps=4.29 w=4 l=2
X189 net7.t25 VINN.t7 net2.t24 VDD.t74 sky130_fd_pr__pfet_01v8_lvt ad=0.58 pd=4.29 as=0.58 ps=4.29 w=4 l=2
X190 net7.t27 VINN.t5 net2.t17 VDD.t62 sky130_fd_pr__pfet_01v8_lvt ad=0.58 pd=4.29 as=0.58 ps=4.29 w=4 l=2
X191 net9.t0 net8.t16 GNDA.t37 GNDA.t36 sky130_fd_pr__nfet_01v8 ad=0.145 pd=1.58 as=0.0725 ps=0.79 w=0.5 l=2
X192 a_12616_6329.t0 a_12994_4519.t0 GNDA.t48 sky130_fd_pr__res_xhigh_po_1p41 l=7.05
X193 a_16212_6577.t0 VDD.t121 a_16058_4519.t0 GNDA.t69 sky130_fd_pr__nfet_01v8 ad=0.145 pd=1.58 as=0.145 ps=1.58 w=0.5 l=10
X194 net3.t3 VBP_CASC.t8 net5.t5 VDD.t16 sky130_fd_pr__pfet_01v8 ad=0.0725 pd=0.79 as=0.0725 ps=0.79 w=0.5 l=0.5
X195 net7.t35 VINP.t25 net1.t19 VDD.t70 sky130_fd_pr__pfet_01v8_lvt ad=0.58 pd=4.29 as=0.58 ps=4.29 w=4 l=2
X196 net3.t13 VINP.t35 net6.t19 GNDA.t58 sky130_fd_pr__nfet_01v8_lvt ad=0.3625 pd=2.79 as=0.3625 ps=2.79 w=2.5 l=2
X197 net7.t16 VINN.t16 net2.t14 VDD.t72 sky130_fd_pr__pfet_01v8_lvt ad=0.58 pd=4.29 as=0.58 ps=4.29 w=4 l=2
X198 VDD.t105 net9.t7 net7.t63 VDD.t104 sky130_fd_pr__pfet_01v8 ad=0.29 pd=2.29 as=0.58 ps=4.58 w=2 l=2
X199 net7.t50 VINP.t10 net1.t16 VDD.t64 sky130_fd_pr__pfet_01v8_lvt ad=0.58 pd=4.29 as=0.58 ps=4.29 w=4 l=2
X200 VDD.t3 net5.t17 net4.t0 VDD.t2 sky130_fd_pr__pfet_01v8 ad=0.29 pd=2.29 as=0.29 ps=2.29 w=2 l=2
X201 VDD.t38 net9.t1 net9.t2 VDD.t37 sky130_fd_pr__pfet_01v8 ad=0.29 pd=2.29 as=0.58 ps=4.58 w=2 l=2
X202 VDD.t18 VBP_TOP.t25 VSTRP_IP.t0 VDD.t17 sky130_fd_pr__pfet_01v8 ad=0.29 pd=2.29 as=0.58 ps=4.58 w=2 l=2
X203 VSTRP_OUT.t0 net14.t3 VDD.t7 VDD.t6 sky130_fd_pr__pfet_01v8 ad=0.29 pd=2.58 as=0.5 ps=3 w=1 l=0.15
X204 net7.t54 VINP.t6 net1.t29 VDD.t68 sky130_fd_pr__pfet_01v8_lvt ad=0.58 pd=4.29 as=1.16 ps=8.58 w=4 l=2
X205 GNDA.t27 net8.t9 net2.t4 GNDA.t26 sky130_fd_pr__nfet_01v8 ad=0.0725 pd=0.79 as=0.0725 ps=0.79 w=0.5 l=2
X206 a_4949_1601.t0 VBN_CASC.t10 GNDA.t53 GNDA.t52 sky130_fd_pr__nfet_01v8 ad=0.0525 pd=0.71 as=0.145 ps=1.58 w=0.5 l=0.5
X207 net1.t6 VBN_CASC.t12 net5.t10 GNDA.t63 sky130_fd_pr__nfet_01v8 ad=0.145 pd=1.58 as=0.0725 ps=0.79 w=0.5 l=0.5
X208 VDD.t60 VBP_TOP.t17 VBP_TOP.t18 VDD.t59 sky130_fd_pr__pfet_01v8 ad=0.29 pd=2.29 as=0.58 ps=4.58 w=2 l=2
X209 VOUT.t2 VBN_CASC.t14 net2.t2 GNDA.t17 sky130_fd_pr__nfet_01v8 ad=0.145 pd=1.58 as=0.0725 ps=0.79 w=0.5 l=0.5
X210 net6.t22 VINP.t31 net3.t17 GNDA.t54 sky130_fd_pr__nfet_01v8_lvt ad=0.3625 pd=2.79 as=0.725 ps=5.58 w=2.5 l=2
X211 a_9970_6199.t0 a_9592_4519.t0 GNDA.t34 sky130_fd_pr__res_xhigh_po_1p41 l=6.4
X212 a_8458_6199.t1 a_8836_4519.t0 GNDA.t33 sky130_fd_pr__res_xhigh_po_1p41 l=6.4
X213 net1.t15 VINP.t5 net7.t55 VDD.t69 sky130_fd_pr__pfet_01v8_lvt ad=0.58 pd=4.29 as=0.58 ps=4.29 w=4 l=2
X214 VDD.t76 net5.t23 net3.t12 VDD.t75 sky130_fd_pr__pfet_01v8 ad=0.29 pd=2.29 as=0.58 ps=4.58 w=2 l=2
X215 net3.t9 VBP_CASC.t20 net5.t1 VDD.t25 sky130_fd_pr__pfet_01v8 ad=0.0725 pd=0.79 as=0.0725 ps=0.79 w=0.5 l=0.5
X216 VSTRP_OUT.t2 net14.t2 a_16520_7473.t0 GNDA.t18 sky130_fd_pr__nfet_01v8 ad=0.29 pd=2.58 as=0.5 ps=3 w=1 l=0.15
X217 net7.t1 net9.t4 VDD.t29 VDD.t28 sky130_fd_pr__pfet_01v8 ad=0.58 pd=4.58 as=0.29 ps=2.29 w=2 l=2
X218 net2.t9 VINN.t15 net7.t17 VDD.t73 sky130_fd_pr__pfet_01v8_lvt ad=0.58 pd=4.29 as=0.58 ps=4.29 w=4 l=2
X219 VDD.t82 EN.t4 net5.t11 VDD.t23 sky130_fd_pr__pfet_01v8 ad=0.58 pd=4.58 as=0.58 ps=4.58 w=2 l=2
X220 GNDA.t45 a_11104_4519.t0 GNDA.t44 sky130_fd_pr__res_xhigh_po_1p41 l=6.4
X221 a_9970_6199.t1 a_10348_4519.t1 GNDA.t81 sky130_fd_pr__res_xhigh_po_1p41 l=6.4
X222 net7.t60 VINP.t0 net1.t32 VDD.t74 sky130_fd_pr__pfet_01v8_lvt ad=0.58 pd=4.29 as=0.58 ps=4.29 w=4 l=2
X223 net4.t19 net5.t14 VDD.t103 VDD.t102 sky130_fd_pr__pfet_01v8 ad=0.29 pd=2.29 as=0.29 ps=2.29 w=2 l=2
X224 VSTRP_IP.t1 VBP_TOP.t22 VDD.t20 VDD.t19 sky130_fd_pr__pfet_01v8 ad=0.29 pd=2.29 as=0.29 ps=2.29 w=2 l=2
R0 VINP.n32 VINP.n18 842.165
R1 VINP.n32 VINP.n12 842.165
R2 VINP.n21 VINP.n19 547.672
R3 VINP.n14 VINP.n13 517.271
R4 VINP.n16 VINP.n15 517.271
R5 VINP.n18 VINP.n17 517.271
R6 VINP.n8 VINP.n7 517.271
R7 VINP.n10 VINP.n9 517.271
R8 VINP.n12 VINP.n11 517.271
R9 VINP.n25 VINP.n23 517.271
R10 VINP.n29 VINP.n27 517.271
R11 VINP.n32 VINP.n31 314.729
R12 VINP.n13 VINP.t21 258.736
R13 VINP.n7 VINP.t0 258.736
R14 VINP.n15 VINP.n14 172.424
R15 VINP.n17 VINP.n16 172.424
R16 VINP.n9 VINP.n8 172.424
R17 VINP.n11 VINP.n10 172.424
R18 VINP.n23 VINP.n21 172.424
R19 VINP.n27 VINP.n25 172.424
R20 VINP.n31 VINP.n29 172.424
R21 VINP.n0 VINP.t28 140.433
R22 VINP VINP.n6 121.805
R23 VINP.n18 VINP.t27 86.3125
R24 VINP.n17 VINP.t26 86.3125
R25 VINP.n16 VINP.t25 86.3125
R26 VINP.n15 VINP.t24 86.3125
R27 VINP.n14 VINP.t23 86.3125
R28 VINP.n13 VINP.t22 86.3125
R29 VINP.n12 VINP.t6 86.3125
R30 VINP.n11 VINP.t5 86.3125
R31 VINP.n10 VINP.t4 86.3125
R32 VINP.n9 VINP.t3 86.3125
R33 VINP.n8 VINP.t2 86.3125
R34 VINP.n7 VINP.t1 86.3125
R35 VINP.n1 VINP.n0 73.2805
R36 VINP.n2 VINP.n1 73.2805
R37 VINP.n3 VINP.n2 73.2805
R38 VINP.n4 VINP.n3 73.2805
R39 VINP.n5 VINP.n4 73.2805
R40 VINP.n6 VINP.n5 73.2805
R41 VINP.n6 VINP.t31 67.153
R42 VINP.n5 VINP.t35 67.153
R43 VINP.n4 VINP.t34 67.153
R44 VINP.n1 VINP.t33 67.153
R45 VINP.n3 VINP.t30 67.153
R46 VINP.n2 VINP.t29 67.153
R47 VINP.n0 VINP.t32 67.153
R48 VINP.n30 VINP.t20 55.9125
R49 VINP.n30 VINP.t13 55.9125
R50 VINP.n28 VINP.t19 55.9125
R51 VINP.n28 VINP.t12 55.9125
R52 VINP.n26 VINP.t18 55.9125
R53 VINP.n26 VINP.t11 55.9125
R54 VINP.n24 VINP.t17 55.9125
R55 VINP.n24 VINP.t10 55.9125
R56 VINP.n22 VINP.t16 55.9125
R57 VINP.n22 VINP.t9 55.9125
R58 VINP.n20 VINP.t15 55.9125
R59 VINP.n20 VINP.t8 55.9125
R60 VINP.n19 VINP.t14 55.9125
R61 VINP.n19 VINP.t7 55.9125
R62 VINP.n21 VINP.n20 30.4005
R63 VINP.n23 VINP.n22 30.4005
R64 VINP.n25 VINP.n24 30.4005
R65 VINP.n27 VINP.n26 30.4005
R66 VINP.n29 VINP.n28 30.4005
R67 VINP.n31 VINP.n30 30.4005
R68 VINP VINP.n32 18.3512
R69 VINN.n27 VINN.t35 584.423
R70 VINN.n33 VINN.n32 546.635
R71 VINN.n29 VINN.n28 517.271
R72 VINN.n31 VINN.n30 517.271
R73 VINN.n26 VINN.n25 453.187
R74 VINN.n26 VINN.n12 452.81
R75 VINN.n33 VINN.n29 374.212
R76 VINN.n30 VINN.t31 239.577
R77 VINN.n28 VINN.n27 172.424
R78 VINN.n32 VINN.n31 172.424
R79 VINN.n0 VINN.t20 168.881
R80 VINN.n13 VINN.t13 168.881
R81 VINN.n0 VINN.t27 86.3125
R82 VINN.n1 VINN.t26 86.3125
R83 VINN.n4 VINN.t25 86.3125
R84 VINN.n2 VINN.t19 86.3125
R85 VINN.n3 VINN.t18 86.3125
R86 VINN.n5 VINN.t24 86.3125
R87 VINN.n8 VINN.t23 86.3125
R88 VINN.n6 VINN.t17 86.3125
R89 VINN.n7 VINN.t16 86.3125
R90 VINN.n9 VINN.t22 86.3125
R91 VINN.n12 VINN.t21 86.3125
R92 VINN.n10 VINN.t15 86.3125
R93 VINN.n11 VINN.t14 86.3125
R94 VINN.n15 VINN.t12 86.3125
R95 VINN.n13 VINN.t6 86.3125
R96 VINN.n14 VINN.t5 86.3125
R97 VINN.n16 VINN.t11 86.3125
R98 VINN.n19 VINN.t10 86.3125
R99 VINN.n17 VINN.t4 86.3125
R100 VINN.n18 VINN.t3 86.3125
R101 VINN.n20 VINN.t9 86.3125
R102 VINN.n23 VINN.t8 86.3125
R103 VINN.n21 VINN.t2 86.3125
R104 VINN.n22 VINN.t1 86.3125
R105 VINN.n24 VINN.t7 86.3125
R106 VINN.n25 VINN.t0 86.3125
R107 VINN.n12 VINN.n11 82.5695
R108 VINN.n11 VINN.n10 82.5695
R109 VINN.n10 VINN.n9 82.5695
R110 VINN.n9 VINN.n8 82.5695
R111 VINN.n8 VINN.n7 82.5695
R112 VINN.n7 VINN.n6 82.5695
R113 VINN.n6 VINN.n5 82.5695
R114 VINN.n5 VINN.n4 82.5695
R115 VINN.n4 VINN.n3 82.5695
R116 VINN.n3 VINN.n2 82.5695
R117 VINN.n2 VINN.n1 82.5695
R118 VINN.n1 VINN.n0 82.5695
R119 VINN.n25 VINN.n24 82.5695
R120 VINN.n24 VINN.n23 82.5695
R121 VINN.n23 VINN.n22 82.5695
R122 VINN.n22 VINN.n21 82.5695
R123 VINN.n21 VINN.n20 82.5695
R124 VINN.n20 VINN.n19 82.5695
R125 VINN.n19 VINN.n18 82.5695
R126 VINN.n18 VINN.n17 82.5695
R127 VINN.n17 VINN.n16 82.5695
R128 VINN.n16 VINN.n15 82.5695
R129 VINN.n15 VINN.n14 82.5695
R130 VINN.n14 VINN.n13 82.5695
R131 VINN.n27 VINN.t34 67.153
R132 VINN.n28 VINN.t33 67.153
R133 VINN.n29 VINN.t32 67.153
R134 VINN.n30 VINN.t30 67.153
R135 VINN.n31 VINN.t29 67.153
R136 VINN.n32 VINN.t28 67.153
R137 VINN.n34 VINN.n33 20.7084
R138 VINN.n34 VINN.n26 19.5203
R139 VINN VINN.n34 1.40462
R140 MN_TAIL_BIAS.n0 MN_TAIL_BIAS.t1 660.59
R141 MN_TAIL_BIAS.n23 MN_TAIL_BIAS.n4 390.776
R142 MN_TAIL_BIAS.n25 MN_TAIL_BIAS.n23 390.776
R143 MN_TAIL_BIAS.n13 MN_TAIL_BIAS.n11 365.176
R144 MN_TAIL_BIAS.n22 MN_TAIL_BIAS.n20 365.176
R145 MN_TAIL_BIAS.n7 MN_TAIL_BIAS.n5 336.83
R146 MN_TAIL_BIAS.n16 MN_TAIL_BIAS.n14 336.83
R147 MN_TAIL_BIAS.n9 MN_TAIL_BIAS.n7 323.012
R148 MN_TAIL_BIAS.n11 MN_TAIL_BIAS.n9 323.012
R149 MN_TAIL_BIAS.n20 MN_TAIL_BIAS.n18 323.012
R150 MN_TAIL_BIAS.n18 MN_TAIL_BIAS.n16 323.012
R151 MN_TAIL_BIAS.n0 MN_TAIL_BIAS.t2 234.938
R152 MN_TAIL_BIAS.n23 MN_TAIL_BIAS.n13 161.506
R153 MN_TAIL_BIAS.n23 MN_TAIL_BIAS.n22 161.506
R154 MN_TAIL_BIAS.n1 MN_TAIL_BIAS.t0 119.347
R155 MN_TAIL_BIAS.n14 MN_TAIL_BIAS.t26 63.5643
R156 MN_TAIL_BIAS.n14 MN_TAIL_BIAS.t18 63.5643
R157 MN_TAIL_BIAS.n15 MN_TAIL_BIAS.t25 63.5643
R158 MN_TAIL_BIAS.n15 MN_TAIL_BIAS.t17 63.5643
R159 MN_TAIL_BIAS.n17 MN_TAIL_BIAS.t24 63.5643
R160 MN_TAIL_BIAS.n17 MN_TAIL_BIAS.t16 63.5643
R161 MN_TAIL_BIAS.n19 MN_TAIL_BIAS.t23 63.5643
R162 MN_TAIL_BIAS.n19 MN_TAIL_BIAS.t15 63.5643
R163 MN_TAIL_BIAS.n21 MN_TAIL_BIAS.t3 63.5643
R164 MN_TAIL_BIAS.n21 MN_TAIL_BIAS.t5 63.5643
R165 MN_TAIL_BIAS.n12 MN_TAIL_BIAS.t7 63.5643
R166 MN_TAIL_BIAS.n12 MN_TAIL_BIAS.t9 63.5643
R167 MN_TAIL_BIAS.n10 MN_TAIL_BIAS.t22 63.5643
R168 MN_TAIL_BIAS.n10 MN_TAIL_BIAS.t14 63.5643
R169 MN_TAIL_BIAS.n8 MN_TAIL_BIAS.t21 63.5643
R170 MN_TAIL_BIAS.n8 MN_TAIL_BIAS.t13 63.5643
R171 MN_TAIL_BIAS.n6 MN_TAIL_BIAS.t20 63.5643
R172 MN_TAIL_BIAS.n6 MN_TAIL_BIAS.t12 63.5643
R173 MN_TAIL_BIAS.n5 MN_TAIL_BIAS.t19 63.5643
R174 MN_TAIL_BIAS.n5 MN_TAIL_BIAS.t11 63.5643
R175 MN_TAIL_BIAS.n7 MN_TAIL_BIAS.n6 13.8187
R176 MN_TAIL_BIAS.n9 MN_TAIL_BIAS.n8 13.8187
R177 MN_TAIL_BIAS.n11 MN_TAIL_BIAS.n10 13.8187
R178 MN_TAIL_BIAS.n13 MN_TAIL_BIAS.n12 13.8187
R179 MN_TAIL_BIAS.n22 MN_TAIL_BIAS.n21 13.8187
R180 MN_TAIL_BIAS.n20 MN_TAIL_BIAS.n19 13.8187
R181 MN_TAIL_BIAS.n18 MN_TAIL_BIAS.n17 13.8187
R182 MN_TAIL_BIAS.n16 MN_TAIL_BIAS.n15 13.8187
R183 MN_TAIL_BIAS.n4 MN_TAIL_BIAS.n2 12.1423
R184 MN_TAIL_BIAS.n26 MN_TAIL_BIAS.n25 12.1423
R185 MN_TAIL_BIAS.n4 MN_TAIL_BIAS.n3 6.37981
R186 MN_TAIL_BIAS.n25 MN_TAIL_BIAS.n24 6.37981
R187 MN_TAIL_BIAS.n2 MN_TAIL_BIAS.n1 5.99785
R188 MN_TAIL_BIAS.n1 MN_TAIL_BIAS.n0 3.938
R189 MN_TAIL_BIAS.n24 MN_TAIL_BIAS.t10 1.7405
R190 MN_TAIL_BIAS.n24 MN_TAIL_BIAS.t6 1.7405
R191 MN_TAIL_BIAS.n3 MN_TAIL_BIAS.t8 1.7405
R192 MN_TAIL_BIAS.n3 MN_TAIL_BIAS.t4 1.7405
R193 MN_TAIL_BIAS.n26 MN_TAIL_BIAS.n2 1.24012
R194 MN_TAIL_BIAS MN_TAIL_BIAS.n26 0.943437
R195 VOUT.n2 VOUT.n0 599.987
R196 VOUT.n2 VOUT.n1 599.33
R197 VOUT.n4 VOUT.n3 599.33
R198 VOUT.n6 VOUT.n5 599.33
R199 VOUT.n7 VOUT.t1 235.008
R200 VOUT.n7 VOUT.t2 234.351
R201 VOUT.n8 VOUT.t10 234.351
R202 VOUT.n0 VOUT.t5 57.1305
R203 VOUT.n0 VOUT.t6 57.1305
R204 VOUT.n1 VOUT.t0 57.1305
R205 VOUT.n1 VOUT.t7 57.1305
R206 VOUT.n3 VOUT.t8 57.1305
R207 VOUT.n3 VOUT.t4 57.1305
R208 VOUT.n5 VOUT.t9 57.1305
R209 VOUT.n5 VOUT.t3 57.1305
R210 VOUT.n9 VOUT.n6 14.1794
R211 VOUT.n9 VOUT.n8 10.3647
R212 VOUT.n8 VOUT.n7 1.45467
R213 VOUT VOUT.n9 1.11851
R214 VOUT.n4 VOUT.n2 0.892167
R215 VOUT.n6 VOUT.n4 0.658833
R216 EN.n5 EN.t0 496.478
R217 EN.n3 EN.t2 458.829
R218 EN.n3 EN.t1 446.209
R219 EN.n1 EN.t3 118.102
R220 EN.n0 EN.t5 80.7828
R221 EN.n2 EN.t6 76.1519
R222 EN.n0 EN.t4 76.1183
R223 EN.n2 EN.n1 7.13383
R224 EN.n4 EN.n2 5.99217
R225 EN.n4 EN.n3 5.09425
R226 EN.n1 EN.n0 3.14633
R227 EN.n5 EN.n4 1.66717
R228 EN EN.n5 0.271333
R229 VDD.n6 VDD.n5 11259.3
R230 VDD.n9 VDD.n6 11259.3
R231 VDD.n9 VDD.n7 11259.3
R232 VDD.n7 VDD.n5 11259.3
R233 VDD.n13 VDD.n4 2053.27
R234 VDD.n13 VDD.n12 2053.27
R235 VDD.n11 VDD.n4 2053.27
R236 VDD.n12 VDD.n11 2053.27
R237 VDD.t8 VDD.t23 1208.31
R238 VDD.n61 VDD.t81 652.538
R239 VDD.n16 VDD.t96 652.468
R240 VDD.n47 VDD.n45 472.471
R241 VDD.t35 VDD.t45 442.498
R242 VDD.t45 VDD.t53 440.786
R243 VDD.n54 VDD.n27 389.272
R244 VDD.n48 VDD.n47 344.848
R245 VDD.n54 VDD.n53 344.848
R246 VDD.n62 VDD.n27 313.976
R247 VDD.n48 VDD.n32 312.471
R248 VDD.t104 VDD.t33 307.923
R249 VDD.t43 VDD.t35 261.164
R250 VDD.t19 VDD.t21 261.164
R251 VDD.t48 VDD.t78 261.164
R252 VDD.t78 VDD.t75 261.164
R253 VDD.t37 VDD.t80 250.9
R254 VDD.n37 VDD.t14 250.129
R255 VDD.n44 VDD.t54 250.129
R256 VDD.n41 VDD.t86 250.129
R257 VDD.n39 VDD.t7 250.129
R258 VDD.t89 VDD.t106 240.637
R259 VDD.t91 VDD.t17 240.637
R260 VDD.t0 VDD.t59 240.637
R261 VDD.n66 VDD.n65 226.148
R262 VDD.n28 VDD.t126 225.744
R263 VDD.n65 VDD.n62 216.847
R264 VDD.t83 VDD.t43 214.406
R265 VDD.t6 VDD.t13 193.879
R266 VDD.t85 VDD.t6 193.879
R267 VDD.t53 VDD.t85 193.879
R268 VDD.t41 VDD.t111 193.879
R269 VDD.t39 VDD.t98 193.879
R270 VDD.t115 VDD.t87 192.738
R271 VDD.t23 VDD.n83 183.043
R272 VDD.n31 VDD.t26 179.623
R273 VDD.t47 VDD.t15 153.963
R274 VDD.t31 VDD.t102 142.558
R275 VDD.t93 VDD.t48 142.558
R276 VDD.n38 VDD.n37 137.3
R277 VDD.n38 VDD.n36 128
R278 VDD.n45 VDD.n36 128
R279 VDD.t67 VDD.n7 118.197
R280 VDD.t68 VDD.n6 118.197
R281 VDD.n21 VDD.t84 115.51
R282 VDD.n66 VDD.t82 115.112
R283 VDD.n46 VDD.t36 115.112
R284 VDD.n68 VDD.t88 115.043
R285 VDD.t4 VDD.t97 109.484
R286 VDD.t100 VDD.t46 109.484
R287 VDD.t74 VDD.t67 105.608
R288 VDD.t73 VDD.t74 105.608
R289 VDD.t66 VDD.t73 105.608
R290 VDD.t65 VDD.t66 105.608
R291 VDD.t72 VDD.t65 105.608
R292 VDD.t71 VDD.t72 105.608
R293 VDD.t64 VDD.t63 105.608
R294 VDD.t63 VDD.t70 105.608
R295 VDD.t70 VDD.t69 105.608
R296 VDD.t69 VDD.t62 105.608
R297 VDD.t62 VDD.t61 105.608
R298 VDD.t61 VDD.t68 105.608
R299 VDD.n64 VDD.n63 100.829
R300 VDD.n58 VDD.n57 100.829
R301 VDD.n55 VDD.n30 100.829
R302 VDD.n52 VDD.n33 100.829
R303 VDD.n49 VDD.n35 100.829
R304 VDD.n1 VDD.n0 99.9855
R305 VDD.n75 VDD.n74 99.9855
R306 VDD.n76 VDD.n73 99.9855
R307 VDD.n77 VDD.n72 99.9855
R308 VDD.n78 VDD.n71 99.9855
R309 VDD.n79 VDD.n70 99.9855
R310 VDD.n81 VDD.n25 99.9855
R311 VDD.n24 VDD.n17 99.9855
R312 VDD.n23 VDD.n18 99.9855
R313 VDD.n22 VDD.n19 99.9855
R314 VDD.n21 VDD.n20 99.9855
R315 VDD.t32 VDD.t31 90.0965
R316 VDD.t97 VDD.t16 90.0965
R317 VDD.t30 VDD.t110 90.0965
R318 VDD.t77 VDD.t57 90.0965
R319 VDD.t57 VDD.t58 90.0965
R320 VDD.t46 VDD.t108 90.0965
R321 VDD.t25 VDD.t93 90.0965
R322 VDD.t109 VDD.t10 80.9729
R323 VDD.t95 VDD.t109 80.9729
R324 VDD.n83 VDD.t50 78.1217
R325 VDD.t80 VDD.t41 77.5515
R326 VDD.t87 VDD.t8 68.4279
R327 VDD.t111 VDD.t39 67.2874
R328 VDD.t98 VDD.t50 67.2874
R329 VDD.t16 VDD.t55 61.5851
R330 VDD.t108 VDD.t11 61.5851
R331 VDD.n31 VDD.t28 61.0149
R332 VDD.t2 VDD.t47 53.6019
R333 VDD.t15 VDD.t113 53.6019
R334 VDD.n8 VDD.t71 52.8039
R335 VDD.n8 VDD.t64 52.8039
R336 VDD.n84 VDD.t30 51.8913
R337 VDD.t10 VDD.t115 50.1806
R338 VDD.t102 VDD.t95 49.0401
R339 VDD.t21 VDD.t83 46.7592
R340 VDD.t110 VDD.t4 44.4783
R341 VDD.t58 VDD.t100 44.4783
R342 VDD.n84 VDD.t94 38.2058
R343 VDD.t94 VDD.t2 36.4951
R344 VDD.t113 VDD.t77 36.4951
R345 VDD.n53 VDD.n32 32.377
R346 VDD.t55 VDD.t32 28.5119
R347 VDD.t11 VDD.t25 28.5119
R348 VDD.t28 VDD.t19 20.5287
R349 VDD.t26 VDD.t89 20.5287
R350 VDD.t106 VDD.t91 20.5287
R351 VDD.t17 VDD.t104 20.5287
R352 VDD.t33 VDD.t0 20.5287
R353 VDD.t59 VDD.t37 20.5287
R354 VDD.n0 VDD.t79 14.283
R355 VDD.n0 VDD.t76 14.283
R356 VDD.n74 VDD.t12 14.283
R357 VDD.n74 VDD.t49 14.283
R358 VDD.n73 VDD.t114 14.283
R359 VDD.n73 VDD.t101 14.283
R360 VDD.n72 VDD.t5 14.283
R361 VDD.n72 VDD.t3 14.283
R362 VDD.n71 VDD.t103 14.283
R363 VDD.n71 VDD.t56 14.283
R364 VDD.n70 VDD.t9 14.283
R365 VDD.n70 VDD.t116 14.283
R366 VDD.n63 VDD.t112 14.283
R367 VDD.n63 VDD.t99 14.283
R368 VDD.n57 VDD.t34 14.283
R369 VDD.n57 VDD.t60 14.283
R370 VDD.n30 VDD.t107 14.283
R371 VDD.n30 VDD.t18 14.283
R372 VDD.n33 VDD.t20 14.283
R373 VDD.n33 VDD.t27 14.283
R374 VDD.n35 VDD.t44 14.283
R375 VDD.n35 VDD.t22 14.283
R376 VDD.n25 VDD.t51 14.283
R377 VDD.n25 VDD.t24 14.283
R378 VDD.n17 VDD.t42 14.283
R379 VDD.n17 VDD.t40 14.283
R380 VDD.n18 VDD.t1 14.283
R381 VDD.n18 VDD.t38 14.283
R382 VDD.n19 VDD.t92 14.283
R383 VDD.n19 VDD.t105 14.283
R384 VDD.n20 VDD.t29 14.283
R385 VDD.n20 VDD.t90 14.283
R386 VDD.n10 VDD.n2 11.7289
R387 VDD.n10 VDD.n3 11.7289
R388 VDD.n14 VDD.n3 11.7289
R389 VDD.n39 VDD.n38 9.3005
R390 VDD.n41 VDD.n36 9.3005
R391 VDD.n45 VDD.n44 9.3005
R392 VDD.n47 VDD.n46 9.3005
R393 VDD.n49 VDD.n48 9.3005
R394 VDD.n53 VDD.n52 9.3005
R395 VDD.n55 VDD.n54 9.3005
R396 VDD.n58 VDD.n27 9.3005
R397 VDD.n62 VDD.n61 9.3005
R398 VDD.n65 VDD.n64 9.3005
R399 VDD.n28 VDD.t52 9.17464
R400 VDD.n86 VDD.n85 8.26774
R401 VDD.n15 VDD.n14 7.49188
R402 VDD.n69 VDD.n67 5.8255
R403 VDD.n40 VDD.n37 5.20883
R404 VDD.n29 VDD.n28 4.72709
R405 VDD.n40 VDD.n39 4.5005
R406 VDD.n42 VDD.n41 4.5005
R407 VDD.n44 VDD.n43 4.5005
R408 VDD.n46 VDD.n34 4.5005
R409 VDD.n50 VDD.n49 4.5005
R410 VDD.n52 VDD.n51 4.5005
R411 VDD.n56 VDD.n55 4.5005
R412 VDD.n59 VDD.n58 4.5005
R413 VDD.n61 VDD.n60 4.5005
R414 VDD.n64 VDD.n26 4.5005
R415 VDD.n67 VDD.n66 4.5005
R416 VDD.n15 VDD.n2 4.23757
R417 VDD.n80 VDD.n79 4.18369
R418 VDD.t118 VDD.t117 3.7119
R419 VDD.t119 VDD.t118 3.7119
R420 VDD.t120 VDD.t119 3.7119
R421 VDD.t121 VDD.t120 3.7119
R422 VDD.t122 VDD.t121 3.7119
R423 VDD.t123 VDD.t122 3.7119
R424 VDD.t124 VDD.t123 3.7119
R425 VDD.t125 VDD.t124 3.7119
R426 VDD.n86 VDD.n15 3.63412
R427 VDD.n69 VDD.n68 3.45524
R428 VDD VDD.n86 3.34964
R429 VDD.n85 VDD.n84 3.33223
R430 VDD.n80 VDD.n69 3.18584
R431 VDD.n7 VDD.n4 3.13609
R432 VDD.n12 VDD.n6 3.13609
R433 VDD.n32 VDD.n31 2.76169
R434 VDD.n85 VDD.n16 2.69447
R435 VDD.n43 VDD.n34 2.61508
R436 VDD.t126 VDD.t125 2.5069
R437 VDD VDD.n1 2.39274
R438 VDD.n23 VDD.n22 2.22895
R439 VDD.n24 VDD.n23 2.22895
R440 VDD.n68 VDD.n16 2.19447
R441 VDD.n59 VDD.n56 2.15467
R442 VDD.n22 VDD.n21 1.97464
R443 VDD.n79 VDD.n78 1.97464
R444 VDD.n78 VDD.n77 1.97464
R445 VDD.n77 VDD.n76 1.97464
R446 VDD.n76 VDD.n75 1.97464
R447 VDD.n75 VDD.n1 1.97464
R448 VDD.n50 VDD.n34 1.90883
R449 VDD.n51 VDD.n50 1.90883
R450 VDD.n13 VDD.n5 1.83218
R451 VDD.n8 VDD.n5 1.83218
R452 VDD.n11 VDD.n9 1.83218
R453 VDD.n9 VDD.n8 1.83218
R454 VDD.n82 VDD.n24 1.77636
R455 VDD.n60 VDD.n59 1.738
R456 VDD.n51 VDD.n29 1.67342
R457 VDD.n83 VDD.n82 1.52602
R458 VDD.n81 VDD.n80 1.37119
R459 VDD.n60 VDD.n26 1.2005
R460 VDD.n67 VDD.n26 1.2005
R461 VDD.n42 VDD.n40 0.708833
R462 VDD.n43 VDD.n42 0.708833
R463 VDD.n56 VDD.n29 0.235917
R464 VDD.n82 VDD.n81 0.198776
R465 VDD.n12 VDD.n2 0.166571
R466 VDD.n4 VDD.n3 0.166571
R467 VDD.n11 VDD.n10 0.0983947
R468 VDD.n14 VDD.n13 0.0983947
R469 GNDA.t15 GNDA.n76 55736
R470 GNDA.n63 GNDA.n21 22624.4
R471 GNDA.n20 GNDA.n19 22624.4
R472 GNDA.n63 GNDA.n20 22624.4
R473 GNDA.n26 GNDA.n19 15420.3
R474 GNDA.n33 GNDA.n26 13389.2
R475 GNDA.n75 GNDA.n11 9537.52
R476 GNDA.n75 GNDA.n12 9537.52
R477 GNDA.n29 GNDA.n12 9537.52
R478 GNDA.n29 GNDA.n11 9537.52
R479 GNDA.n26 GNDA.n21 7204.09
R480 GNDA.n31 GNDA.n30 3922.92
R481 GNDA.n62 GNDA.n22 2512.19
R482 GNDA.n25 GNDA.n22 2512.19
R483 GNDA.n62 GNDA.n61 2512.19
R484 GNDA.n60 GNDA.n25 1709.18
R485 GNDA.n60 GNDA.n59 1484.05
R486 GNDA.t24 GNDA.t39 1458.51
R487 GNDA.n30 GNDA.t57 1360.35
R488 GNDA.n76 GNDA.t54 1360.35
R489 GNDA.t21 GNDA.t19 1267.31
R490 GNDA.t57 GNDA.t61 1248.57
R491 GNDA.t61 GNDA.t60 1248.57
R492 GNDA.t60 GNDA.t56 1248.57
R493 GNDA.t55 GNDA.t59 1248.57
R494 GNDA.t59 GNDA.t58 1248.57
R495 GNDA.t58 GNDA.t54 1248.57
R496 GNDA.n15 GNDA.n13 1061.65
R497 GNDA.n73 GNDA.n15 1061.65
R498 GNDA.n74 GNDA.n13 1061.65
R499 GNDA.n74 GNDA.n73 1061.65
R500 GNDA.t39 GNDA.t36 1018.29
R501 GNDA.t30 GNDA.t21 1018.29
R502 GNDA.t19 GNDA.t15 1018.29
R503 GNDA.n61 GNDA.n60 803.013
R504 GNDA.t56 GNDA.n28 624.288
R505 GNDA.n28 GNDA.t55 624.288
R506 GNDA.t77 GNDA.t24 622.538
R507 GNDA.t13 GNDA.t10 600.303
R508 GNDA.t36 GNDA.n31 564.731
R509 GNDA.t26 GNDA.t52 471.349
R510 GNDA.n31 GNDA.n27 460.937
R511 GNDA.n77 GNDA.t17 389.086
R512 GNDA.n32 GNDA.t114 346.842
R513 GNDA.t5 GNDA.t77 315.716
R514 GNDA.t51 GNDA.t14 315.716
R515 GNDA.t6 GNDA.t51 315.716
R516 GNDA.t80 GNDA.t6 315.716
R517 GNDA.t52 GNDA.t101 315.716
R518 GNDA.t114 GNDA.t26 275.695
R519 GNDA.t10 GNDA.t30 275.695
R520 GNDA.n20 GNDA.t84 268.277
R521 GNDA.n32 GNDA.t63 253.462
R522 GNDA.t14 GNDA.t3 235.675
R523 GNDA.t101 GNDA.t11 231.228
R524 GNDA.n38 GNDA.t74 230.143
R525 GNDA.n51 GNDA.t40 230.138
R526 GNDA.n10 GNDA.t53 229.851
R527 GNDA.n67 GNDA.t29 229.803
R528 GNDA.t38 GNDA.t103 215.637
R529 GNDA.t104 GNDA.t78 215.637
R530 GNDA.t78 GNDA.t102 215.637
R531 GNDA.t50 GNDA.t35 215.637
R532 GNDA.t44 GNDA.t50 215.637
R533 GNDA.t47 GNDA.t46 215.637
R534 GNDA.t34 GNDA.t81 215.637
R535 GNDA.n77 GNDA.t41 211.219
R536 GNDA.t7 GNDA.t41 208.994
R537 GNDA.t17 GNDA.t1 208.994
R538 GNDA.t103 GNDA.t94 204.798
R539 GNDA.n8 GNDA.n7 197.739
R540 GNDA.t64 GNDA.t95 197.381
R541 GNDA.n52 GNDA.n35 195.339
R542 GNDA.n53 GNDA.n34 195.339
R543 GNDA.n57 GNDA.n54 195.339
R544 GNDA.n56 GNDA.n55 195.339
R545 GNDA.n1 GNDA.n0 195.339
R546 GNDA.n81 GNDA.n2 195.339
R547 GNDA.n80 GNDA.n3 195.339
R548 GNDA.n79 GNDA.n4 195.339
R549 GNDA.n9 GNDA.n5 195.339
R550 GNDA.n8 GNDA.n6 195.339
R551 GNDA.t87 GNDA.t34 192.248
R552 GNDA.t0 GNDA.t86 180.839
R553 GNDA.t90 GNDA.t49 169.429
R554 GNDA.n27 GNDA.t0 142.617
R555 GNDA.t63 GNDA.t7 142.294
R556 GNDA.t1 GNDA.t13 142.294
R557 GNDA.t48 GNDA.n64 140.335
R558 GNDA.t46 GNDA.t89 139.764
R559 GNDA.t88 GNDA.t47 134.06
R560 GNDA.t108 GNDA.t42 123.791
R561 GNDA.t111 GNDA.t43 112.382
R562 GNDA.t102 GNDA.t92 111.242
R563 GNDA.t33 GNDA.t111 103.254
R564 GNDA.n37 GNDA.t83 96.8989
R565 GNDA.n18 GNDA.t106 96.8989
R566 GNDA.n39 GNDA.t85 96.8989
R567 GNDA.t43 GNDA.t108 91.8454
R568 GNDA.t71 GNDA.t70 87.8522
R569 GNDA.t69 GNDA.t68 87.8522
R570 GNDA.t67 GNDA.t66 87.8522
R571 GNDA.t66 GNDA.t65 87.8522
R572 GNDA.t65 GNDA.t64 87.8522
R573 GNDA.t11 GNDA.t80 84.4876
R574 GNDA.t81 GNDA.t88 81.5771
R575 GNDA.t3 GNDA.t5 80.0409
R576 GNDA.n65 GNDA.t92 79.2952
R577 GNDA.t97 GNDA.t72 78.7247
R578 GNDA.t89 GNDA.t44 75.8724
R579 GNDA.t70 GNDA.t82 69.0268
R580 GNDA.t95 GNDA.t38 69.0268
R581 GNDA.n69 GNDA.n17 66.8989
R582 GNDA.t68 GNDA.t96 59.3289
R583 GNDA.t84 GNDA.t73 55.3356
R584 GNDA.t72 GNDA.t18 50.7719
R585 GNDA.t35 GNDA.t90 46.2082
R586 GNDA.n64 GNDA.t28 38.7922
R587 GNDA.t18 GNDA.t71 37.0808
R588 GNDA.t49 GNDA.t28 36.5103
R589 GNDA.n35 GNDA.t79 34.8005
R590 GNDA.n35 GNDA.t23 34.8005
R591 GNDA.n34 GNDA.t12 34.8005
R592 GNDA.n34 GNDA.t27 34.8005
R593 GNDA.n54 GNDA.t62 34.8005
R594 GNDA.n54 GNDA.t2 34.8005
R595 GNDA.n55 GNDA.t113 34.8005
R596 GNDA.n55 GNDA.t22 34.8005
R597 GNDA.n0 GNDA.t20 34.8005
R598 GNDA.n0 GNDA.t16 34.8005
R599 GNDA.n2 GNDA.t75 34.8005
R600 GNDA.n2 GNDA.t100 34.8005
R601 GNDA.n3 GNDA.t31 34.8005
R602 GNDA.n3 GNDA.t110 34.8005
R603 GNDA.n4 GNDA.t8 34.8005
R604 GNDA.n4 GNDA.t9 34.8005
R605 GNDA.n5 GNDA.t107 34.8005
R606 GNDA.n5 GNDA.t32 34.8005
R607 GNDA.n6 GNDA.t25 34.8005
R608 GNDA.n6 GNDA.t4 34.8005
R609 GNDA.n7 GNDA.t37 34.8005
R610 GNDA.n7 GNDA.t76 34.8005
R611 GNDA.t86 GNDA.t33 34.7989
R612 GNDA.t96 GNDA.t105 27.9533
R613 GNDA.n29 GNDA.n15 26.5914
R614 GNDA.n30 GNDA.n29 26.5914
R615 GNDA.n75 GNDA.n74 26.5914
R616 GNDA.n76 GNDA.n75 26.5914
R617 GNDA.n65 GNDA.t48 25.101
R618 GNDA.t42 GNDA.t87 23.3896
R619 GNDA.t82 GNDA.t69 18.8259
R620 GNDA.n17 GNDA.t109 17.4005
R621 GNDA.n17 GNDA.t112 17.4005
R622 GNDA.n42 GNDA.t91 14.6469
R623 GNDA.n43 GNDA.t93 14.6469
R624 GNDA.n46 GNDA.t98 14.6469
R625 GNDA.n47 GNDA.t99 14.6469
R626 GNDA.n41 GNDA.n23 13.591
R627 GNDA.n44 GNDA.n43 12.1713
R628 GNDA.n42 GNDA.n41 12.1713
R629 GNDA.n48 GNDA.n47 12.1713
R630 GNDA.n46 GNDA.n36 12.1713
R631 GNDA.n68 GNDA.t45 11.687
R632 GNDA.n78 GNDA.n77 11.4546
R633 GNDA.t94 GNDA.t104 10.8393
R634 GNDA.n49 GNDA.n48 10.5738
R635 GNDA.n40 GNDA.n23 9.78498
R636 GNDA.n50 GNDA.n49 9.78498
R637 GNDA.n13 GNDA.n11 9.7505
R638 GNDA.n28 GNDA.n11 9.7505
R639 GNDA.n73 GNDA.n12 9.7505
R640 GNDA.n28 GNDA.n12 9.7505
R641 GNDA.n66 GNDA.n65 9.43931
R642 GNDA.n22 GNDA.n20 9.28621
R643 GNDA.n61 GNDA.n21 9.28621
R644 GNDA.n27 GNDA.n21 9.28621
R645 GNDA.t73 GNDA.t97 9.12795
R646 GNDA.n40 GNDA.n39 7.313
R647 GNDA.n70 GNDA.n69 6.86472
R648 GNDA.n72 GNDA.n71 6.05222
R649 GNDA.n72 GNDA.n14 6.05222
R650 GNDA.n16 GNDA.n14 6.05222
R651 GNDA GNDA.n81 5.99188
R652 GNDA.n66 GNDA.n18 5.84317
R653 GNDA.n70 GNDA.n16 5.18584
R654 GNDA.n59 GNDA.n33 5.13208
R655 GNDA.n33 GNDA.n32 5.13208
R656 GNDA.n69 GNDA.n68 4.94878
R657 GNDA.n63 GNDA.n62 4.43232
R658 GNDA.n64 GNDA.n63 4.43232
R659 GNDA.n25 GNDA.n19 4.43232
R660 GNDA.n64 GNDA.n19 4.43232
R661 GNDA.n44 GNDA.n40 3.80653
R662 GNDA.n36 GNDA.n24 3.78283
R663 GNDA.n48 GNDA.n45 3.78283
R664 GNDA.n43 GNDA.n42 3.5755
R665 GNDA.n47 GNDA.n46 3.5755
R666 GNDA GNDA.n1 3.13843
R667 GNDA.n51 GNDA.n50 2.78283
R668 GNDA.n52 GNDA.n51 2.40136
R669 GNDA.n9 GNDA.n8 2.21602
R670 GNDA.n81 GNDA.n80 2.21602
R671 GNDA.n53 GNDA.n52 2.21602
R672 GNDA.n56 GNDA.n1 2.21602
R673 GNDA.n67 GNDA.n66 2.21386
R674 GNDA.n80 GNDA.n79 1.97464
R675 GNDA.n57 GNDA.n56 1.97464
R676 GNDA.n78 GNDA.n10 1.68153
R677 GNDA.n38 GNDA.n37 1.39705
R678 GNDA.n58 GNDA.n53 1.09748
R679 GNDA.n68 GNDA.n67 1.05438
R680 GNDA.n58 GNDA.n57 0.877655
R681 GNDA.n50 GNDA.n36 0.789293
R682 GNDA.n41 GNDA.n24 0.765586
R683 GNDA.n45 GNDA.n44 0.765586
R684 GNDA.n71 GNDA.n70 0.741879
R685 GNDA.n37 GNDA.n18 0.733259
R686 GNDA.t105 GNDA.t67 0.570965
R687 GNDA.n74 GNDA.n14 0.443357
R688 GNDA.n71 GNDA.n15 0.443357
R689 GNDA.n10 GNDA.n9 0.207397
R690 GNDA.n73 GNDA.n72 0.163658
R691 GNDA.n16 GNDA.n13 0.163658
R692 GNDA.n45 GNDA.n22 0.1555
R693 GNDA.n61 GNDA.n24 0.1555
R694 GNDA.n79 GNDA.n78 0.0867069
R695 GNDA.n59 GNDA.n58 0.0866111
R696 GNDA.n62 GNDA.n23 0.0749
R697 GNDA.n49 GNDA.n25 0.0749
R698 GNDA.n39 GNDA.n38 0.0694655
R699 a_5801_1601.t0 a_5801_1601.t1 50.4005
R700 a_5659_1601.t0 a_5659_1601.t1 50.4005
R701 a_5517_1601.t0 a_5517_1601.t1 50.4005
R702 a_5375_1601.t0 a_5375_1601.t1 50.4005
R703 a_5233_1601.t0 a_5233_1601.t1 50.4005
R704 a_5091_1601.t0 a_5091_1601.t1 50.4005
R705 a_4949_1601.t0 a_4949_1601.t1 50.4005
R706 a_16674_4519.t0 a_16674_4519.t1 497.577
R707 a_16366_4519.t0 a_16366_4519.t1 497.577
R708 a_16058_4519.t0 a_16058_4519.t1 497.577
R709 a_15750_4519.t0 a_15750_4519.t1 497.577
R710 a_15442_4519.t0 a_15442_4519.t1 497.577
R711 a_16520_6577.t0 a_16520_6577.t1 497.577
R712 a_16212_6577.t0 a_16212_6577.t1 497.577
R713 a_15904_6577.t0 a_15904_6577.t1 497.577
R714 a_15596_6577.t0 a_15596_6577.t1 497.577
R715 a_14506_4519.t0 a_14506_4519.t1 1.69014
R716 a_14128_6329.t0 a_14128_6329.t1 21.2079
R717 a_13750_4519.t0 a_13750_4519.t1 1.69014
R718 a_13372_6329.t0 a_13372_6329.t1 21.2079
R719 a_12994_4519.t0 a_12994_4519.t1 1.69014
R720 a_12616_6329.t0 a_12616_6329.t1 21.2079
R721 a_12238_4519.t0 a_12238_4519.t1 1.69014
R722 a_11860_6329.t0 a_11860_6329.t1 21.2079
R723 a_11104_4519.t0 a_11104_4519.t1 1.69014
R724 a_10726_6199.t0 a_10726_6199.t1 21.2079
R725 a_10348_4519.t0 a_10348_4519.t1 1.69014
R726 a_9970_6199.t0 a_9970_6199.t1 21.2079
R727 a_9592_4519.t0 a_9592_4519.t1 1.69014
R728 a_9214_6199.t0 a_9214_6199.t1 21.2079
R729 a_8836_4519.t0 a_8836_4519.t1 1.69014
R730 net12.n1 net12.t14 17.2604
R731 net12.n9 net12.t8 17.2604
R732 net12.n6 net12.t5 13.9208
R733 net12.n14 net12.t12 13.9208
R734 net12.n3 net12.t10 13.6854
R735 net12.n2 net12.t4 13.6854
R736 net12.n11 net12.t15 13.6854
R737 net12.n10 net12.t13 13.6854
R738 net12.n5 net12.n4 11.9454
R739 net12.n1 net12.n0 11.9454
R740 net12.n13 net12.n12 11.9454
R741 net12.n9 net12.n8 11.9454
R742 net12.n7 net12.t0 9.71497
R743 net12.n3 net12.n2 4.04217
R744 net12.n11 net12.n10 4.04217
R745 net12.n2 net12.n1 3.5755
R746 net12.n5 net12.n3 3.5755
R747 net12.n10 net12.n9 3.5755
R748 net12.n13 net12.n11 3.5755
R749 net12.n15 net12.n14 3.4105
R750 net12.n7 net12.n6 3.4105
R751 net12.n6 net12.n5 3.34008
R752 net12.n14 net12.n13 3.34008
R753 net12.n4 net12.t2 1.7405
R754 net12.n4 net12.t3 1.7405
R755 net12.n0 net12.t6 1.7405
R756 net12.n0 net12.t1 1.7405
R757 net12.n12 net12.t7 1.7405
R758 net12.n12 net12.t16 1.7405
R759 net12.n8 net12.t9 1.7405
R760 net12.n8 net12.t11 1.7405
R761 net12.n15 net12.n7 1.24012
R762 net12 net12.n15 0.01225
R763 net2.n0 net2.t5 34.8005
R764 net2.n0 net2.t0 34.8005
R765 net2.n1 net2.n0 203.435
R766 net2.n35 net2.n1 8.50633
R767 net2 net2.n34 0.01225
R768 net2.n34 net2.n35 0.586825
R769 net2.n35 net2.n31 0.213175
R770 net2.n31 net2.n28 0.763662
R771 net2.n28 net2.n21 0.567438
R772 net2.n21 net2.n14 0.5457
R773 net2.n34 net2.n33 10.4147
R774 net2.n33 net2.n32 199.618
R775 net2.n32 net2.t34 34.8005
R776 net2.n32 net2.t4 34.8005
R777 net2.n33 net2.t3 238.234
R778 net2.n31 net2.n30 10.3605
R779 net2.n30 net2.t36 233.84
R780 net2.n30 net2.n29 200.495
R781 net2.n29 net2.t1 34.8005
R782 net2.n29 net2.t2 34.8005
R783 net2.n26 net2.n24 3.81717
R784 net2.n27 net2.n26 3.81717
R785 net2.n28 net2.n27 4.68967
R786 net2.n27 net2.t29 66.1498
R787 net2.n26 net2.n25 59.0085
R788 net2.n25 net2.t13 7.14175
R789 net2.n25 net2.t22 7.14175
R790 net2.n24 net2.n23 59.0085
R791 net2.n23 net2.t6 7.14175
R792 net2.n23 net2.t28 7.14175
R793 net2.n24 net2.n22 62.8252
R794 net2.n22 net2.t11 7.14175
R795 net2.n22 net2.t17 7.14175
R796 net2.n18 net2.n16 3.81717
R797 net2.n20 net2.n18 3.81717
R798 net2.n21 net2.n20 6.598
R799 net2.n20 net2.n19 59.0085
R800 net2.n19 net2.t26 7.14175
R801 net2.n19 net2.t24 7.14175
R802 net2.n18 net2.n17 59.0085
R803 net2.n17 net2.t32 7.14175
R804 net2.n17 net2.t31 7.14175
R805 net2.n16 net2.n15 59.0085
R806 net2.n15 net2.t10 7.14175
R807 net2.n15 net2.t8 7.14175
R808 net2.n16 net2.t15 69.9665
R809 net2.n11 net2.n9 3.81717
R810 net2.n13 net2.n11 3.81717
R811 net2.n14 net2.n13 6.598
R812 net2.n13 net2.n12 59.0085
R813 net2.n12 net2.t9 7.14175
R814 net2.n12 net2.t18 7.14175
R815 net2.n11 net2.n10 59.0085
R816 net2.n10 net2.t30 7.14175
R817 net2.n10 net2.t14 7.14175
R818 net2.n9 net2.n8 59.0085
R819 net2.n8 net2.t7 7.14175
R820 net2.n8 net2.t33 7.14175
R821 net2.n9 net2.t21 69.9665
R822 net2.n6 net2.n4 3.81717
R823 net2.n7 net2.n6 3.81717
R824 net2.n14 net2.n7 5.2566
R825 net2.n7 net2.t19 66.1498
R826 net2.n6 net2.n5 59.0085
R827 net2.n5 net2.t25 7.14175
R828 net2.n5 net2.t27 7.14175
R829 net2.n4 net2.n3 59.0085
R830 net2.n3 net2.t16 7.14175
R831 net2.n3 net2.t23 7.14175
R832 net2.n4 net2.n2 62.8252
R833 net2.n2 net2.t20 7.14175
R834 net2.n2 net2.t12 7.14175
R835 net2.n1 net2.t35 234.417
R836 net1.n0 net1.t36 34.8005
R837 net1.n0 net1.t0 34.8005
R838 net1.n1 net1.n0 199.329
R839 net1.n35 net1.n1 9.873
R840 net1 net1.n35 0.01225
R841 net1.n35 net1.n34 0.445825
R842 net1.n34 net1.n31 0.213175
R843 net1.n31 net1.n28 0.599162
R844 net1.n28 net1.n21 0.567438
R845 net1.n21 net1.n14 0.5457
R846 net1.n34 net1.n32 7.96467
R847 net1.n32 net1.n33 203.147
R848 net1.n33 net1.t1 34.8005
R849 net1.n33 net1.t4 34.8005
R850 net1.n32 net1.t35 234.13
R851 net1.n31 net1.n29 9.81883
R852 net1.n29 net1.n30 1.1255
R853 net1.n30 net1.t6 234.787
R854 net1.n30 net1.t5 234.13
R855 net1.n29 net1.t2 234.13
R856 net1.n28 net1.n22 4.148
R857 net1.n22 net1.n24 3.81717
R858 net1.n24 net1.n26 3.81717
R859 net1.n26 net1.n27 62.8252
R860 net1.n27 net1.t20 7.14175
R861 net1.n27 net1.t32 7.14175
R862 net1.n26 net1.n25 59.0085
R863 net1.n25 net1.t23 7.14175
R864 net1.n25 net1.t13 7.14175
R865 net1.n24 net1.n23 59.0085
R866 net1.n23 net1.t15 7.14175
R867 net1.n23 net1.t26 7.14175
R868 net1.n22 net1.t29 66.1498
R869 net1.n21 net1.n16 6.05633
R870 net1.n16 net1.n18 3.81717
R871 net1.n18 net1.n20 3.81717
R872 net1.n20 net1.t8 69.9665
R873 net1.n20 net1.n19 59.0085
R874 net1.n19 net1.t24 7.14175
R875 net1.n19 net1.t9 7.14175
R876 net1.n18 net1.n17 59.0085
R877 net1.n17 net1.t21 7.14175
R878 net1.n17 net1.t16 7.14175
R879 net1.n16 net1.n15 59.0085
R880 net1.n15 net1.t18 7.14175
R881 net1.n15 net1.t7 7.14175
R882 net1.n14 net1.n9 6.05633
R883 net1.n9 net1.n11 3.81717
R884 net1.n11 net1.n13 3.81717
R885 net1.n13 net1.t22 69.9665
R886 net1.n13 net1.n12 59.0085
R887 net1.n12 net1.t25 7.14175
R888 net1.n12 net1.t14 7.14175
R889 net1.n11 net1.n10 59.0085
R890 net1.n10 net1.t31 7.14175
R891 net1.n10 net1.t30 7.14175
R892 net1.n9 net1.n8 59.0085
R893 net1.n8 net1.t17 7.14175
R894 net1.n8 net1.t33 7.14175
R895 net1.n14 net1.n2 4.71494
R896 net1.n2 net1.n4 3.81717
R897 net1.n4 net1.n6 3.81717
R898 net1.n6 net1.n7 62.8252
R899 net1.n7 net1.t11 7.14175
R900 net1.n7 net1.t34 7.14175
R901 net1.n6 net1.n5 59.0085
R902 net1.n5 net1.t10 7.14175
R903 net1.n5 net1.t12 7.14175
R904 net1.n4 net1.n3 59.0085
R905 net1.n3 net1.t28 7.14175
R906 net1.n3 net1.t19 7.14175
R907 net1.n2 net1.t27 66.1498
R908 net1.n1 net1.t3 237.946
R909 a_8458_6199.t0 a_8458_6199.t1 21.2079
R910 a_16520_7473.t0 a_16520_7473.t1 443.675
R911 net6.n0 net6.t0 233.84
R912 net6.n22 net6.n2 3.4105
R913 net6.n2 net6.n1 3.09633
R914 net6.n2 net6.n0 3.09633
R915 net6.n17 net6.n16 3.4105
R916 net6.n21 net6.n20 3.4105
R917 net6 net6.n21 0.01225
R918 net6.n21 net6.n22 0.304825
R919 net6.n22 net6.n17 3.32105
R920 net6.n17 net6.n9 3.7959
R921 net6.n20 net6.n18 3.09633
R922 net6.n20 net6.n19 3.09633
R923 net6.n19 net6.t14 235.75
R924 net6.n19 net6.t3 233.84
R925 net6.n18 net6.t2 233.84
R926 net6.n18 net6.t1 235.75
R927 net6.n16 net6.n12 0.954667
R928 net6.n16 net6.n14 0.954667
R929 net6.n14 net6.n15 34.166
R930 net6.n15 net6.t11 6.9605
R931 net6.n15 net6.t18 6.9605
R932 net6.n14 net6.n13 32.2576
R933 net6.n13 net6.t20 6.9605
R934 net6.n13 net6.t12 6.9605
R935 net6.n12 net6.n11 32.2576
R936 net6.n11 net6.t5 6.9605
R937 net6.n11 net6.t21 6.9605
R938 net6.n12 net6.n10 34.166
R939 net6.n10 net6.t22 6.9605
R940 net6.n10 net6.t7 6.9605
R941 net6.n9 net6.n5 0.954667
R942 net6.n9 net6.n7 0.954667
R943 net6.n7 net6.n8 34.166
R944 net6.n8 net6.t17 6.9605
R945 net6.n8 net6.t8 6.9605
R946 net6.n7 net6.n6 32.2576
R947 net6.n6 net6.t6 6.9605
R948 net6.n6 net6.t15 6.9605
R949 net6.n5 net6.n4 32.2576
R950 net6.n4 net6.t16 6.9605
R951 net6.n4 net6.t10 6.9605
R952 net6.n5 net6.n3 34.166
R953 net6.n3 net6.t9 6.9605
R954 net6.n3 net6.t19 6.9605
R955 net6.n0 net6.t4 235.75
R956 net6.n1 net6.t13 233.84
R957 net6.n1 net6.t23 235.75
R958 net15 net15.t0 660.438
R959 net15 net15.t1 19.3188
R960 VSTRP_OUT.t0 VSTRP_OUT.n0 228.577
R961 VSTRP_OUT.n1 VSTRP_OUT.n0 4.5005
R962 VSTRP_OUT VSTRP_OUT.n2 0.0421667
R963 VSTRP_OUT.n2 VSTRP_OUT.n1 1.93592
R964 VSTRP_OUT.n1 VSTRP_OUT.t1 233.785
R965 VSTRP_OUT.n2 VSTRP_OUT.t3 248.829
R966 VSTRP_OUT.n0 VSTRP_OUT.t2 85.1739
R967 EN_B.t0 EN_B.n4 83.7172
R968 EN_B.n0 EN_B.n4 4.86108
R969 EN_B EN_B.n2 0.0421667
R970 EN_B.n2 EN_B.n3 7.688
R971 EN_B.n3 EN_B.n0 5.68592
R972 EN_B.n3 EN_B.t2 323.961
R973 EN_B.n2 EN_B.n1 166.62
R974 EN_B.n1 EN_B.t3 49.078
R975 EN_B.n1 EN_B.t4 248.131
R976 EN_B.n0 EN_B.t5 467.546
R977 EN_B.n4 EN_B.t1 230.032
R978 net14.t0 net14.n0 228.864
R979 net14.n1 net14.n0 4.5005
R980 net14 net14.n1 0.0421667
R981 net14.n1 net14.n2 6.14425
R982 net14.n2 net14.t2 445.166
R983 net14.n2 net14.t3 459.873
R984 net14.n0 net14.t1 84.8854
R985 VSTRP_IP.t6 VSTRP_IP 237.781
R986 VSTRP_IP VSTRP_IP.n7 3.42225
R987 VSTRP_IP.n3 VSTRP_IP.n1 1.90883
R988 VSTRP_IP.n5 VSTRP_IP.n3 1.90883
R989 VSTRP_IP.n7 VSTRP_IP.n5 2.74008
R990 VSTRP_IP.n7 VSTRP_IP.n6 5.78383
R991 VSTRP_IP.n6 VSTRP_IP.t8 444.877
R992 VSTRP_IP.n6 VSTRP_IP.t9 460.161
R993 VSTRP_IP.n5 VSTRP_IP.n4 105.038
R994 VSTRP_IP.n4 VSTRP_IP.t5 14.283
R995 VSTRP_IP.n4 VSTRP_IP.t4 14.283
R996 VSTRP_IP.n3 VSTRP_IP.n2 105.038
R997 VSTRP_IP.n2 VSTRP_IP.t1 14.283
R998 VSTRP_IP.n2 VSTRP_IP.t2 14.283
R999 VSTRP_IP.n1 VSTRP_IP.n0 105.038
R1000 VSTRP_IP.n0 VSTRP_IP.t7 14.283
R1001 VSTRP_IP.n0 VSTRP_IP.t3 14.283
R1002 VSTRP_IP.n1 VSTRP_IP.t0 121.23
R1003 net8.n0 net8.t1 219.8
R1004 net8.n0 net8.n15 33.1299
R1005 net8.n5 net8.n4 41.285
R1006 net8.n6 net8.n5 51.3808
R1007 net8.n7 net8.n6 41.285
R1008 net8.n8 net8.n7 41.285
R1009 net8.n9 net8.n8 41.285
R1010 net8.n10 net8.n9 41.285
R1011 net8.n11 net8.n10 41.285
R1012 net8.n12 net8.n11 51.3808
R1013 net8.n13 net8.n12 41.285
R1014 net8.n15 net8.n13 38.4906
R1015 net8.n15 net8.n14 20.6428
R1016 net8.n14 net8.t16 158.21
R1017 net8.n14 net8.t5 43.053
R1018 net8.n13 net8.t6 43.053
R1019 net8.n12 net8.t7 43.053
R1020 net8.n11 net8.t8 43.053
R1021 net8.n10 net8.t9 43.053
R1022 net8.n9 net8.t10 43.053
R1023 net8.n8 net8.t11 43.053
R1024 net8.n7 net8.t12 43.053
R1025 net8.n6 net8.t13 43.053
R1026 net8.n5 net8.t14 43.053
R1027 net8.n4 net8.t15 43.053
R1028 net8.n14 net8.t0 43.053
R1029 net8.n13 net8.t17 43.053
R1030 net8.n12 net8.t18 43.053
R1031 net8.n11 net8.t19 43.053
R1032 net8.n10 net8.t20 43.053
R1033 net8.n9 net8.t21 43.053
R1034 net8.n8 net8.t22 43.053
R1035 net8.n7 net8.t23 43.053
R1036 net8.n6 net8.t24 43.053
R1037 net8.n5 net8.t25 43.053
R1038 net8.n4 net8.t26 43.053
R1039 net8.n3 net8.n0 18.4509
R1040 net8 net8.n3 0.01225
R1041 net8.n2 net8.n1 4.5005
R1042 net8.n3 net8.n2 11.6269
R1043 net8.n2 net8.t4 120.653
R1044 net8.n1 net8.t3 85.1386
R1045 net8.n1 net8.t2 114.209
R1046 a_5881_8229.t0 a_5881_8229.t1 82.7405
R1047 a_5739_8229.t0 a_5739_8229.t1 82.7405
R1048 VBP_CASC.n20 VBP_CASC.t0 238.207
R1049 VBP_CASC VBP_CASC.n20 0.01225
R1050 VBP_CASC.n20 VBP_CASC.n0 16.5564
R1051 VBP_CASC.n0 VBP_CASC.n19 70.3503
R1052 VBP_CASC.n2 VBP_CASC.n1 59.4829
R1053 VBP_CASC.n3 VBP_CASC.n2 59.4829
R1054 VBP_CASC.n4 VBP_CASC.n3 101.647
R1055 VBP_CASC.n5 VBP_CASC.n4 59.4829
R1056 VBP_CASC.n6 VBP_CASC.n5 59.4829
R1057 VBP_CASC.n7 VBP_CASC.n6 59.4829
R1058 VBP_CASC.n8 VBP_CASC.n7 101.647
R1059 VBP_CASC.n9 VBP_CASC.n8 59.4829
R1060 VBP_CASC.n10 VBP_CASC.n9 59.4829
R1061 VBP_CASC.n11 VBP_CASC.n10 59.4829
R1062 VBP_CASC.n12 VBP_CASC.n11 101.647
R1063 VBP_CASC.n13 VBP_CASC.n12 59.4829
R1064 VBP_CASC.n14 VBP_CASC.n13 59.4829
R1065 VBP_CASC.n15 VBP_CASC.n14 59.4829
R1066 VBP_CASC.n16 VBP_CASC.n15 126.495
R1067 VBP_CASC.n17 VBP_CASC.n16 53.4593
R1068 VBP_CASC.n18 VBP_CASC.n17 53.4593
R1069 VBP_CASC.n19 VBP_CASC.n18 54.9652
R1070 VBP_CASC.n18 VBP_CASC.t1 206.948
R1071 VBP_CASC.n17 VBP_CASC.t4 206.948
R1072 VBP_CASC.n16 VBP_CASC.t5 206.948
R1073 VBP_CASC.n15 VBP_CASC.t6 206.948
R1074 VBP_CASC.n14 VBP_CASC.t7 206.948
R1075 VBP_CASC.n13 VBP_CASC.t8 206.948
R1076 VBP_CASC.n12 VBP_CASC.t9 206.948
R1077 VBP_CASC.n11 VBP_CASC.t10 206.948
R1078 VBP_CASC.n10 VBP_CASC.t11 206.948
R1079 VBP_CASC.n9 VBP_CASC.t12 206.948
R1080 VBP_CASC.n8 VBP_CASC.t13 206.948
R1081 VBP_CASC.n7 VBP_CASC.t14 206.948
R1082 VBP_CASC.n6 VBP_CASC.t15 206.948
R1083 VBP_CASC.n5 VBP_CASC.t16 206.948
R1084 VBP_CASC.n4 VBP_CASC.t17 206.948
R1085 VBP_CASC.n3 VBP_CASC.t18 206.948
R1086 VBP_CASC.n2 VBP_CASC.t19 206.948
R1087 VBP_CASC.n1 VBP_CASC.t20 206.948
R1088 VBP_CASC.n1 VBP_CASC.t21 266.43
R1089 VBP_CASC.n19 VBP_CASC.t2 642.13
R1090 VBP_CASC.n0 VBP_CASC.t3 111.784
R1091 VBP_TOP.t0 VBP_TOP.n0 651.883
R1092 VBP_TOP.n0 VBP_TOP.n16 2.90347
R1093 VBP_TOP.n16 VBP_TOP.n26 92.9887
R1094 VBP_TOP.n26 VBP_TOP.n17 272.188
R1095 VBP_TOP.n26 VBP_TOP.n18 86.2123
R1096 VBP_TOP.n18 VBP_TOP.n19 172.424
R1097 VBP_TOP.n19 VBP_TOP.n20 216.847
R1098 VBP_TOP.n20 VBP_TOP.n21 172.424
R1099 VBP_TOP.n21 VBP_TOP.n22 172.424
R1100 VBP_TOP.n22 VBP_TOP.n23 172.424
R1101 VBP_TOP.n23 VBP_TOP.n24 172.424
R1102 VBP_TOP.n24 VBP_TOP.n25 172.424
R1103 VBP_TOP.n25 VBP_TOP.t19 234.637
R1104 VBP_TOP.n25 VBP_TOP.t20 62.2125
R1105 VBP_TOP.n24 VBP_TOP.t21 62.2125
R1106 VBP_TOP.n23 VBP_TOP.t22 62.2125
R1107 VBP_TOP.n22 VBP_TOP.t23 62.2125
R1108 VBP_TOP.n21 VBP_TOP.t24 62.2125
R1109 VBP_TOP.n20 VBP_TOP.t25 62.2125
R1110 VBP_TOP.n19 VBP_TOP.t26 62.2125
R1111 VBP_TOP.n18 VBP_TOP.t17 62.2125
R1112 VBP_TOP.n17 VBP_TOP.t27 62.2125
R1113 VBP_TOP.n17 VBP_TOP.t28 234.637
R1114 VBP_TOP.n16 VBP_TOP.t18 111.784
R1115 VBP_TOP VBP_TOP.n0 8.08267
R1116 VBP_TOP.n8 VBP_TOP.n7 3.4105
R1117 VBP_TOP.n8 VBP_TOP.n15 4.65012
R1118 VBP_TOP VBP_TOP.n8 2.7406
R1119 VBP_TOP.n15 VBP_TOP.n11 1.79425
R1120 VBP_TOP.n11 VBP_TOP.n13 7.61717
R1121 VBP_TOP.n13 VBP_TOP.n14 15.0396
R1122 VBP_TOP.n14 VBP_TOP.t15 1.7405
R1123 VBP_TOP.n14 VBP_TOP.t16 1.7405
R1124 VBP_TOP.n13 VBP_TOP.n12 11.4646
R1125 VBP_TOP.n12 VBP_TOP.t13 1.7405
R1126 VBP_TOP.n12 VBP_TOP.t14 1.7405
R1127 VBP_TOP.n11 VBP_TOP.n10 11.4646
R1128 VBP_TOP.n10 VBP_TOP.t11 1.7405
R1129 VBP_TOP.n10 VBP_TOP.t12 1.7405
R1130 VBP_TOP.n15 VBP_TOP.n9 13.2459
R1131 VBP_TOP.n9 VBP_TOP.t9 1.7405
R1132 VBP_TOP.n9 VBP_TOP.t10 1.7405
R1133 VBP_TOP.n7 VBP_TOP.n3 1.79425
R1134 VBP_TOP.n3 VBP_TOP.n5 7.61717
R1135 VBP_TOP.n5 VBP_TOP.n6 15.0396
R1136 VBP_TOP.n6 VBP_TOP.t7 1.7405
R1137 VBP_TOP.n6 VBP_TOP.t8 1.7405
R1138 VBP_TOP.n5 VBP_TOP.n4 11.4646
R1139 VBP_TOP.n4 VBP_TOP.t5 1.7405
R1140 VBP_TOP.n4 VBP_TOP.t6 1.7405
R1141 VBP_TOP.n3 VBP_TOP.n2 11.4646
R1142 VBP_TOP.n2 VBP_TOP.t3 1.7405
R1143 VBP_TOP.n2 VBP_TOP.t4 1.7405
R1144 VBP_TOP.n7 VBP_TOP.n1 13.2459
R1145 VBP_TOP.n1 VBP_TOP.t1 1.7405
R1146 VBP_TOP.n1 VBP_TOP.t2 1.7405
R1147 VBN_CASC.t2 VBN_CASC.n0 219.8
R1148 VBN_CASC.n4 VBN_CASC.n3 59.4829
R1149 VBN_CASC.n5 VBN_CASC.n4 101.647
R1150 VBN_CASC.n6 VBN_CASC.n5 59.4829
R1151 VBN_CASC.n7 VBN_CASC.n6 101.647
R1152 VBN_CASC.n8 VBN_CASC.n7 126.495
R1153 VBN_CASC.n9 VBN_CASC.n8 53.4593
R1154 VBN_CASC.n10 VBN_CASC.n9 53.4593
R1155 VBN_CASC.n11 VBN_CASC.n10 53.4593
R1156 VBN_CASC.n12 VBN_CASC.n11 53.4593
R1157 VBN_CASC.n13 VBN_CASC.n12 53.4593
R1158 VBN_CASC.n14 VBN_CASC.n13 53.4593
R1159 VBN_CASC.n15 VBN_CASC.n14 53.4593
R1160 VBN_CASC.n0 VBN_CASC.n15 62.8711
R1161 VBN_CASC.n15 VBN_CASC.t1 202.611
R1162 VBN_CASC.n14 VBN_CASC.t4 202.611
R1163 VBN_CASC.n13 VBN_CASC.t5 202.611
R1164 VBN_CASC.n12 VBN_CASC.t6 202.611
R1165 VBN_CASC.n11 VBN_CASC.t7 202.611
R1166 VBN_CASC.n10 VBN_CASC.t8 202.611
R1167 VBN_CASC.n9 VBN_CASC.t9 202.611
R1168 VBN_CASC.n8 VBN_CASC.t10 202.611
R1169 VBN_CASC.n7 VBN_CASC.t11 202.611
R1170 VBN_CASC.n6 VBN_CASC.t12 202.611
R1171 VBN_CASC.n5 VBN_CASC.t13 202.611
R1172 VBN_CASC.n4 VBN_CASC.t14 202.611
R1173 VBN_CASC.n3 VBN_CASC.t15 202.611
R1174 VBN_CASC.n3 VBN_CASC.t16 304.257
R1175 VBN_CASC.n2 VBN_CASC.n0 19.0477
R1176 VBN_CASC VBN_CASC.n2 0.01225
R1177 VBN_CASC.n2 VBN_CASC.n1 3.5208
R1178 VBN_CASC.n1 VBN_CASC.t3 98.5398
R1179 VBN_CASC.n1 VBN_CASC.t0 132.617
R1180 net7.n0 net7.t60 7.14175
R1181 net7.n0 net7.t32 7.14175
R1182 net7.n1 net7.n0 58.5278
R1183 net7.n6 net7.n4 1.90883
R1184 net7.n8 net7.n6 1.90883
R1185 net7.n10 net7.n8 1.90883
R1186 net7.n12 net7.n10 1.90883
R1187 net7.n1 net7.n12 1.90883
R1188 net7.n62 net7.n1 6.3105
R1189 net7 net7.n62 0.01225
R1190 net7.n62 net7.n61 0.567438
R1191 net7.n61 net7.n47 0.5457
R1192 net7.n47 net7.n33 0.567438
R1193 net7.n52 net7.n50 1.90883
R1194 net7.n54 net7.n52 1.90883
R1195 net7.n56 net7.n54 1.90883
R1196 net7.n58 net7.n56 1.90883
R1197 net7.n60 net7.n58 1.90883
R1198 net7.n61 net7.n60 6.3105
R1199 net7.n60 net7.n59 58.5278
R1200 net7.n59 net7.t25 7.14175
R1201 net7.n59 net7.t53 7.14175
R1202 net7.n58 net7.n57 58.5278
R1203 net7.n57 net7.t52 7.14175
R1204 net7.n57 net7.t24 7.14175
R1205 net7.n56 net7.n55 58.5278
R1206 net7.n55 net7.t23 7.14175
R1207 net7.n55 net7.t51 7.14175
R1208 net7.n54 net7.n53 58.5278
R1209 net7.n53 net7.t50 7.14175
R1210 net7.n53 net7.t22 7.14175
R1211 net7.n52 net7.n51 58.5278
R1212 net7.n51 net7.t21 7.14175
R1213 net7.n51 net7.t49 7.14175
R1214 net7.n50 net7.n49 58.5278
R1215 net7.n49 net7.t48 7.14175
R1216 net7.n49 net7.t20 7.14175
R1217 net7.n50 net7.n48 60.4361
R1218 net7.n48 net7.t19 7.14175
R1219 net7.n48 net7.t47 7.14175
R1220 net7.n38 net7.n36 1.90883
R1221 net7.n40 net7.n38 1.90883
R1222 net7.n42 net7.n40 1.90883
R1223 net7.n44 net7.n42 1.90883
R1224 net7.n46 net7.n44 1.90883
R1225 net7.n47 net7.n46 6.3105
R1226 net7.n46 net7.n45 58.5278
R1227 net7.n45 net7.t18 7.14175
R1228 net7.n45 net7.t46 7.14175
R1229 net7.n44 net7.n43 58.5278
R1230 net7.n43 net7.t45 7.14175
R1231 net7.n43 net7.t17 7.14175
R1232 net7.n42 net7.n41 58.5278
R1233 net7.n41 net7.t16 7.14175
R1234 net7.n41 net7.t44 7.14175
R1235 net7.n40 net7.n39 58.5278
R1236 net7.n39 net7.t43 7.14175
R1237 net7.n39 net7.t15 7.14175
R1238 net7.n38 net7.n37 58.5278
R1239 net7.n37 net7.t14 7.14175
R1240 net7.n37 net7.t42 7.14175
R1241 net7.n36 net7.n35 58.5278
R1242 net7.n35 net7.t41 7.14175
R1243 net7.n35 net7.t13 7.14175
R1244 net7.n36 net7.n34 60.4361
R1245 net7.n34 net7.t12 7.14175
R1246 net7.n34 net7.t40 7.14175
R1247 net7.n24 net7.n22 1.90883
R1248 net7.n26 net7.n24 1.90883
R1249 net7.n28 net7.n26 1.90883
R1250 net7.n30 net7.n28 1.90883
R1251 net7.n32 net7.n30 1.90883
R1252 net7.n33 net7.n32 6.3105
R1253 net7.n32 net7.n31 58.5278
R1254 net7.n31 net7.t39 7.14175
R1255 net7.n31 net7.t11 7.14175
R1256 net7.n30 net7.n29 58.5278
R1257 net7.n29 net7.t10 7.14175
R1258 net7.n29 net7.t38 7.14175
R1259 net7.n28 net7.n27 58.5278
R1260 net7.n27 net7.t37 7.14175
R1261 net7.n27 net7.t9 7.14175
R1262 net7.n26 net7.n25 58.5278
R1263 net7.n25 net7.t8 7.14175
R1264 net7.n25 net7.t36 7.14175
R1265 net7.n24 net7.n23 58.5278
R1266 net7.n23 net7.t35 7.14175
R1267 net7.n23 net7.t7 7.14175
R1268 net7.n22 net7.n21 58.5278
R1269 net7.n21 net7.t6 7.14175
R1270 net7.n21 net7.t34 7.14175
R1271 net7.n22 net7.n20 60.4361
R1272 net7.n20 net7.t33 7.14175
R1273 net7.n20 net7.t5 7.14175
R1274 net7.n33 net7.n13 5.99015
R1275 net7.n13 net7.n15 1.90883
R1276 net7.n15 net7.n16 1.90883
R1277 net7.n16 net7.n17 2.4005
R1278 net7.n17 net7.n19 1.90883
R1279 net7.n19 net7.t1 120.34
R1280 net7.n19 net7.n18 104.148
R1281 net7.n18 net7.t62 14.283
R1282 net7.n18 net7.t61 14.283
R1283 net7.n17 net7.t63 118.431
R1284 net7.n16 net7.t3 118.431
R1285 net7.n15 net7.n14 104.148
R1286 net7.n14 net7.t4 14.283
R1287 net7.n14 net7.t2 14.283
R1288 net7.n13 net7.t0 118.431
R1289 net7.n12 net7.n11 58.5278
R1290 net7.n11 net7.t31 7.14175
R1291 net7.n11 net7.t59 7.14175
R1292 net7.n10 net7.n9 58.5278
R1293 net7.n9 net7.t58 7.14175
R1294 net7.n9 net7.t30 7.14175
R1295 net7.n8 net7.n7 58.5278
R1296 net7.n7 net7.t29 7.14175
R1297 net7.n7 net7.t57 7.14175
R1298 net7.n6 net7.n5 58.5278
R1299 net7.n5 net7.t56 7.14175
R1300 net7.n5 net7.t28 7.14175
R1301 net7.n4 net7.n3 58.5278
R1302 net7.n3 net7.t27 7.14175
R1303 net7.n3 net7.t55 7.14175
R1304 net7.n4 net7.n2 60.4361
R1305 net7.n2 net7.t54 7.14175
R1306 net7.n2 net7.t26 7.14175
R1307 net4.t8 net4.n0 656.75
R1308 net4.n4 net4.n3 4.5005
R1309 net4.n9 net4.n7 0.658833
R1310 net4.n4 net4.n9 0.7755
R1311 net4.n11 net4.n4 0.7755
R1312 net4.n0 net4.n11 0.658833
R1313 net4.n6 net4.n0 2.38383
R1314 net4.n15 net4.n6 5.40155
R1315 net4 net4.n19 0.01225
R1316 net4.n19 net4.n15 0.3859
R1317 net4.n19 net4.n18 6.5855
R1318 net4.n18 net4.n17 32.5701
R1319 net4.n17 net4.t16 6.9605
R1320 net4.n17 net4.t17 6.9605
R1321 net4.n18 net4.n16 36.3868
R1322 net4.n16 net4.t14 6.9605
R1323 net4.n16 net4.t15 6.9605
R1324 net4.n14 net4.n13 3.81717
R1325 net4.n15 net4.n14 4.67717
R1326 net4.n14 net4.t13 39.5301
R1327 net4.n13 net4.n12 32.5701
R1328 net4.n12 net4.t11 6.9605
R1329 net4.n12 net4.t12 6.9605
R1330 net4.n13 net4.t10 43.3468
R1331 net4.n11 net4.n10 599.62
R1332 net4.n10 net4.t6 57.1305
R1333 net4.n10 net4.t7 57.1305
R1334 net4.n9 net4.n8 599.62
R1335 net4.n8 net4.t2 57.1305
R1336 net4.n8 net4.t3 57.1305
R1337 net4.n7 net4.t1 656.75
R1338 net4.n6 net4.n5 104.93
R1339 net4.n5 net4.t19 14.283
R1340 net4.n5 net4.t21 14.283
R1341 net4.n3 net4.t5 652.283
R1342 net4.n3 net4.t4 652.283
R1343 net4.n3 net4.n2 100.353
R1344 net4.n2 net4.t20 14.283
R1345 net4.n2 net4.t0 14.283
R1346 net4.n7 net4.n1 107.314
R1347 net4.n1 net4.t18 14.283
R1348 net4.n1 net4.t9 14.283
R1349 net3.t20 net3.n2 43.3468
R1350 net3.n20 net3.n0 5.84383
R1351 net3.n0 net3.n2 3.81717
R1352 net3 net3.n20 0.01225
R1353 net3.n20 net3.n19 0.3859
R1354 net3.n19 net3.n17 7.75217
R1355 net3.n17 net3.n18 36.3868
R1356 net3.n18 net3.t15 6.9605
R1357 net3.n18 net3.t16 6.9605
R1358 net3.n17 net3.n16 32.5701
R1359 net3.n16 net3.t13 6.9605
R1360 net3.n16 net3.t14 6.9605
R1361 net3.n6 net3.n5 4.5005
R1362 net3.n9 net3.n8 4.5005
R1363 net3.n19 net3.n3 4.74214
R1364 net3.n3 net3.n10 2.74217
R1365 net3.n10 net3.n12 0.658833
R1366 net3.n12 net3.n6 0.417167
R1367 net3.n6 net3.n9 3.81717
R1368 net3.n9 net3.n14 0.417167
R1369 net3.n14 net3.n15 0.658833
R1370 net3.n15 net3.t4 656.462
R1371 net3.n14 net3.n13 599.332
R1372 net3.n13 net3.t3 57.1305
R1373 net3.n13 net3.t7 57.1305
R1374 net3.n12 net3.n11 599.332
R1375 net3.n11 net3.t9 57.1305
R1376 net3.n11 net3.t6 57.1305
R1377 net3.n10 net3.t8 656.462
R1378 net3.n15 net3.t1 122.243
R1379 net3.n8 net3.t2 652.111
R1380 net3.n8 net3.n7 100.641
R1381 net3.n7 net3.t0 14.283
R1382 net3.n7 net3.t11 14.283
R1383 net3.n5 net3.t5 652.111
R1384 net3.n5 net3.n4 100.641
R1385 net3.n4 net3.t10 14.283
R1386 net3.n4 net3.t21 14.283
R1387 net3.n3 net3.t12 119.501
R1388 net3.n2 net3.n1 32.5701
R1389 net3.n1 net3.t18 6.9605
R1390 net3.n1 net3.t19 6.9605
R1391 net3.n0 net3.t17 39.5301
R1392 net9.t0 net9.n11 239.114
R1393 net9 net9.n11 0.01225
R1394 net9.n11 net9.n10 15.6061
R1395 net9.n10 net9.t3 125.314
R1396 net9.n10 net9.n0 6.3605
R1397 net9.n0 net9.n9 92.9887
R1398 net9.n2 net9.n1 172.424
R1399 net9.n3 net9.n2 172.424
R1400 net9.n9 net9.n3 130.636
R1401 net9.n9 net9.n4 86.2123
R1402 net9.n4 net9.n5 172.424
R1403 net9.n5 net9.n6 216.847
R1404 net9.n6 net9.n7 172.424
R1405 net9.n7 net9.n8 172.424
R1406 net9.n8 net9.t4 234.637
R1407 net9.n8 net9.t5 62.2125
R1408 net9.n7 net9.t6 62.2125
R1409 net9.n6 net9.t7 62.2125
R1410 net9.n5 net9.t8 62.2125
R1411 net9.n4 net9.t1 62.2125
R1412 net9.n3 net9.t9 62.2125
R1413 net9.n2 net9.t10 62.2125
R1414 net9.n1 net9.t11 62.2125
R1415 net9.n1 net9.t12 234.637
R1416 net9.n0 net9.t2 111.784
R1417 net5.n0 net5.t6 57.1305
R1418 net5.n0 net5.t7 57.1305
R1419 net5.n1 net5.n0 599.617
R1420 net5.n22 net5.n3 8.50633
R1421 net5.n3 net5.n5 0.658833
R1422 net5.n5 net5.n7 3.99217
R1423 net5.n7 net5.n1 0.658833
R1424 net5 net5.n21 0.01225
R1425 net5.n21 net5.n22 3.5819
R1426 net5.n21 net5.n19 9.823
R1427 net5.n19 net5.n20 201.046
R1428 net5.n20 net5.t9 34.8005
R1429 net5.n20 net5.t10 34.8005
R1430 net5.n19 net5.t8 234.062
R1431 net5.n22 net5.n8 469.858
R1432 net5.n8 net5.n9 172.424
R1433 net5.n9 net5.n10 172.424
R1434 net5.n10 net5.n11 172.424
R1435 net5.n11 net5.n12 172.424
R1436 net5.n12 net5.n13 172.424
R1437 net5.n13 net5.n14 172.424
R1438 net5.n14 net5.n15 172.424
R1439 net5.n15 net5.n16 172.424
R1440 net5.n16 net5.n17 172.424
R1441 net5.n17 net5.n18 172.424
R1442 net5.n18 net5.t12 234.637
R1443 net5.n18 net5.t13 62.2125
R1444 net5.n17 net5.t14 62.2125
R1445 net5.n16 net5.t15 62.2125
R1446 net5.n15 net5.t16 62.2125
R1447 net5.n14 net5.t17 62.2125
R1448 net5.n13 net5.t18 62.2125
R1449 net5.n12 net5.t19 62.2125
R1450 net5.n11 net5.t20 62.2125
R1451 net5.n10 net5.t21 62.2125
R1452 net5.n9 net5.t22 62.2125
R1453 net5.n8 net5.t23 62.2125
R1454 net5.n7 net5.n6 599.617
R1455 net5.n6 net5.t4 57.1305
R1456 net5.n6 net5.t5 57.1305
R1457 net5.n5 net5.n4 599.617
R1458 net5.n4 net5.t2 57.1305
R1459 net5.n4 net5.t3 57.1305
R1460 net5.n3 net5.n2 599.617
R1461 net5.n2 net5.t0 57.1305
R1462 net5.n2 net5.t1 57.1305
R1463 net5.n1 net5.t11 125.853
C0 VINP net7 10.0064f
C1 net6 VBN_CASC 0.05249f
C2 VINN net3 0.70668f
C3 VDD VBP_CASC 3.79574f
C4 net2 net12 0.00905f
C5 net5 VINP 1.69304f
C6 VBP_TOP net12 6.13805f
C7 net14 EN 0.12405f
C8 VSTRP_IP EN 0.10385f
C9 VBN_CASC EN_B 0.25548f
C10 EN net3 0.21336f
C11 VSTRP_OUT EN_B 0.24133f
C12 VDD VINN 12.1979f
C13 net7 VOUT 2.90769f
C14 VDD EN 4.8447f
C15 net1 net7 11.9548f
C16 net5 VOUT 2.94184f
C17 net2 net4 0.03057f
C18 net1 net5 2.48504f
C19 VINP VOUT 0.13906f
C20 net1 VINP 11.2082f
C21 net9 net7 4.93763f
C22 net6 net3 3.46724f
C23 net5 net9 0.06576f
C24 net14 EN_B 0.11446f
C25 VSTRP_IP EN_B 0.1266f
C26 net8 net12 0.00139f
C27 net6 VDD 0.17991f
C28 net1 VOUT 0.45578f
C29 net9 VINP 0.10649f
C30 MN_TAIL_BIAS VBN_CASC 0.00288f
C31 VDD EN_B 3.61986f
C32 MN_TAIL_BIAS VSTRP_OUT 0.2215f
C33 net8 net4 0
C34 net9 VOUT 0.09674f
C35 net1 net9 0.11431f
C36 net2 VBN_CASC 1.10712f
C37 VBP_TOP VBN_CASC 0.01335f
C38 VBP_CASC net7 0.27354f
C39 VSTRP_OUT VBP_TOP 0.00236f
C40 net5 VBP_CASC 0.65889f
C41 VINN net7 10.4822f
C42 VINP VBP_CASC 0.15441f
C43 net5 VINN 0.21733f
C44 EN net7 1.41463f
C45 VSTRP_IP MN_TAIL_BIAS 1.54162f
C46 net5 EN 0.47206f
C47 VINN VINP 13.3685f
C48 VDD MN_TAIL_BIAS 1.93315f
C49 VBP_CASC VOUT 0.79285f
C50 net1 VBP_CASC 0.13387f
C51 net2 net3 0.27651f
C52 EN net15 0.00135f
C53 VSTRP_IP VBP_TOP 1.1328f
C54 VINN VOUT 0.69002f
C55 net8 VBN_CASC 0.11954f
C56 net1 VINN 3.06693f
C57 EN VOUT 0.00956f
C58 net6 net7 0.47148f
C59 net2 VDD 5.19692f
C60 VDD VBP_TOP 7.37882f
C61 net9 VBP_CASC 3.40944f
C62 net5 net6 0.07806f
C63 net7 EN_B 0.01622f
C64 net9 VINN 0.33414f
C65 net6 VINP 2.95085f
C66 net9 EN 1.23863f
C67 net4 VBN_CASC 0.93134f
C68 EN_B net15 0.08667f
C69 net6 VOUT 0.09286f
C70 net8 net3 0
C71 net1 net6 4.1286f
C72 EN_B VOUT 0
C73 VDD net8 2.16555f
C74 net6 net9 0
C75 VDD net12 0.03394f
C76 VINN VBP_CASC 0.24168f
C77 MN_TAIL_BIAS net7 0.03228f
C78 net9 EN_B 0.00264f
C79 net4 net3 3.74465f
C80 EN VBP_CASC 0.20212f
C81 EN VINN 0.07552f
C82 VDD net4 1.944f
C83 net2 net7 13.1609f
C84 MN_TAIL_BIAS net15 0.21057f
C85 VBP_TOP net7 0.06186f
C86 net2 net5 0.27541f
C87 MN_TAIL_BIAS VOUT 0.1093f
C88 net1 MN_TAIL_BIAS 0
C89 net2 VINP 2.66882f
C90 net6 VBP_CASC 0.06824f
C91 VBP_TOP net15 0
C92 net6 VINN 2.87259f
C93 net2 VOUT 3.26308f
C94 net9 MN_TAIL_BIAS 0.00699f
C95 VBP_TOP VOUT 0.00115f
C96 VINN EN_B 0
C97 net1 net2 7.77324f
C98 VBN_CASC net3 0.12551f
C99 EN EN_B 0.76572f
C100 net14 VSTRP_OUT 0.8894f
C101 VSTRP_IP VSTRP_OUT 0.12023f
C102 net8 net7 0.36743f
C103 net5 net8 0.20888f
C104 VDD VBN_CASC 1.82743f
C105 net2 net9 0.71463f
C106 net9 VBP_TOP 2.3028f
C107 VDD VSTRP_OUT 2.39819f
C108 net7 net12 0.40608f
C109 net8 VINP 0.14324f
C110 VINP net12 0
C111 net4 net7 0
C112 MN_TAIL_BIAS VBP_CASC 0
C113 net8 VOUT 0.53124f
C114 net5 net4 2.04727f
C115 net14 VSTRP_IP 0.54919f
C116 net1 net8 0.62603f
C117 MN_TAIL_BIAS VINN 0.00195f
C118 net12 VOUT 0.23969f
C119 VINP net4 0.61333f
C120 net14 VDD 1.4752f
C121 VSTRP_IP VDD 4.91145f
C122 net1 net12 0
C123 VDD net3 3.09482f
C124 EN MN_TAIL_BIAS 0.40134f
C125 net2 VBP_CASC 0.56289f
C126 net9 net8 0.32688f
C127 net4 VOUT 0.46691f
C128 net2 VINN 11.6312f
C129 net9 net12 0
C130 net1 net4 0
C131 EN VBP_TOP 1.22318f
C132 net9 net4 0.00232f
C133 VBN_CASC net7 0.88994f
C134 MN_TAIL_BIAS EN_B 0.25789f
C135 net5 VBN_CASC 0.57848f
C136 net8 VBP_CASC 3.74413f
C137 net2 net6 1.33707f
C138 VINP VBN_CASC 0.55616f
C139 net8 VINN 0.86039f
C140 VBP_CASC net12 0
C141 VSTRP_OUT net15 0.05913f
C142 VBP_TOP EN_B 0.18339f
C143 EN net8 0.39767f
C144 VINN net12 0.00256f
C145 VBN_CASC VOUT 0.47969f
C146 net1 VBN_CASC 0.33027f
C147 net4 VBP_CASC 0.64595f
C148 VSTRP_IP net7 0.00915f
C149 net7 net3 0.02782f
C150 net5 net3 2.27697f
C151 VINN net4 2.44386f
C152 VDD net7 9.24142f
C153 net9 VBN_CASC 6.02766f
C154 VINP net3 2.61304f
C155 net5 VDD 13.0516f
C156 EN net4 0.16095f
C157 net6 net8 1.96582f
C158 net14 net15 0.00438f
C159 VSTRP_IP net15 0.44706f
C160 VDD VINP 15.5542f
C161 net8 EN_B 0.08622f
C162 net3 VOUT 0.33982f
C163 VDD net15 0.46803f
C164 net2 MN_TAIL_BIAS 0.01193f
C165 MN_TAIL_BIAS VBP_TOP 20.2365f
C166 net1 net3 0.01214f
C167 VDD VOUT 1.65351f
C168 net1 VDD 5.18733f
C169 net6 net4 3.3967f
C170 VSTRP_IP net9 0.01073f
C171 net9 net3 0.122f
C172 net2 VBP_TOP 0
C173 VBP_CASC VBN_CASC 0.10704f
C174 net9 VDD 8.15925f
C175 VINN VBN_CASC 0.86767f
C176 EN VBN_CASC 0.10924f
C177 EN VSTRP_OUT 0.239f
C178 MN_TAIL_BIAS net8 0.00262f
C179 MN_TAIL_BIAS net12 18.8581f
C180 net5 net7 0.09176f
C181 VBP_CASC net3 0.86825f
C182 net2 net8 1.27262f
C183 net8 VBP_TOP 0.44833f
C184 VINP GNDA 7.15602f
C185 VINN GNDA 8.12071f
C186 MN_TAIL_BIAS GNDA 28.88296f
C187 VOUT GNDA 2.38252f
C188 EN GNDA 1.02683f
C189 VDD GNDA 0.19184p
C190 net12 GNDA 19.80023f
C191 net2 GNDA 4.87596f
C192 net1 GNDA 3.95788f
C193 net6 GNDA 4.0508f
C194 net15 GNDA 2.0054f
C195 VSTRP_OUT GNDA 0.18915f
C196 EN_B GNDA 5.52434f
C197 net14 GNDA 0.42292f
C198 VSTRP_IP GNDA 1.91521f
C199 net8 GNDA 11.58076f
C200 VBP_CASC GNDA 0.60394f
C201 VBP_TOP GNDA 8.53292f
C202 VBN_CASC GNDA 5.32201f
C203 net7 GNDA 0.02645f
C204 net4 GNDA 1.88549f
C205 net3 GNDA 1.9285f
C206 net9 GNDA 1.38768f
C207 net5 GNDA 3.29053f
C208 net5.t7 GNDA 0.00971f
C209 net5.n0 GNDA 0.02122f
C210 net5.n1 GNDA 1.79272f
C211 net5.t11 GNDA 0.20926f
C212 net5.t0 GNDA 0.00971f
C213 net5.t1 GNDA 0.00971f
C214 net5.n2 GNDA 0.02122f
C215 net5.n3 GNDA 0.92588f
C216 net5.t2 GNDA 0.00971f
C217 net5.t3 GNDA 0.00971f
C218 net5.n4 GNDA 0.02122f
C219 net5.n5 GNDA 0.61647f
C220 net5.t4 GNDA 0.00971f
C221 net5.t5 GNDA 0.00971f
C222 net5.n6 GNDA 0.02122f
C223 net5.n7 GNDA 0.61647f
C224 net5.t23 GNDA 1.03554f
C225 net5.n8 GNDA 0.42074f
C226 net5.t22 GNDA 1.03554f
C227 net5.n9 GNDA 0.33025f
C228 net5.t21 GNDA 1.03554f
C229 net5.n10 GNDA 0.33025f
C230 net5.t20 GNDA 1.03554f
C231 net5.n11 GNDA 0.33025f
C232 net5.t19 GNDA 1.03554f
C233 net5.n12 GNDA 0.33025f
C234 net5.t18 GNDA 1.03554f
C235 net5.n13 GNDA 0.33025f
C236 net5.t17 GNDA 1.03554f
C237 net5.n14 GNDA 0.33025f
C238 net5.t16 GNDA 1.03554f
C239 net5.n15 GNDA 0.33025f
C240 net5.t15 GNDA 1.03554f
C241 net5.n16 GNDA 0.33025f
C242 net5.t14 GNDA 1.03554f
C243 net5.n17 GNDA 0.33025f
C244 net5.t13 GNDA 1.03554f
C245 net5.n18 GNDA 0.41607f
C246 net5.t12 GNDA 1.27338f
C247 net5.t8 GNDA 0.03794f
C248 net5.n19 GNDA 1.59629f
C249 net5.t9 GNDA 0.00971f
C250 net5.t10 GNDA 0.00971f
C251 net5.n20 GNDA 0.02763f
C252 net5.n21 GNDA 2.05147f
C253 net5.n22 GNDA 2.59676f
C254 net5.t6 GNDA 0.00971f
C255 net9.t0 GNDA 0.05891f
C256 net9.n0 GNDA 0.23735f
C257 net9.t2 GNDA 0.17734f
C258 net9.t12 GNDA 1.60769f
C259 net9.t11 GNDA 1.30741f
C260 net9.n1 GNDA 0.5253f
C261 net9.t10 GNDA 1.30741f
C262 net9.n2 GNDA 0.41696f
C263 net9.t9 GNDA 1.30741f
C264 net9.n3 GNDA 0.401f
C265 net9.t1 GNDA 1.30741f
C266 net9.n4 GNDA 0.38405f
C267 net9.t8 GNDA 1.30741f
C268 net9.n5 GNDA 0.43392f
C269 net9.t7 GNDA 1.30741f
C270 net9.n6 GNDA 0.43392f
C271 net9.t6 GNDA 1.30741f
C272 net9.n7 GNDA 0.41696f
C273 net9.t5 GNDA 1.30741f
C274 net9.n8 GNDA 0.5253f
C275 net9.t4 GNDA 1.60769f
C276 net9.n9 GNDA 0.11828f
C277 net9.n10 GNDA 4.25842f
C278 net9.t3 GNDA 0.25917f
C279 net9.n11 GNDA 5.63751f
C280 net3.t20 GNDA 0.376f
C281 net3.t17 GNDA 0.29403f
C282 net3.n0 GNDA 1.45228f
C283 net3.t18 GNDA 0.06889f
C284 net3.t19 GNDA 0.06889f
C285 net3.n1 GNDA 0.20436f
C286 net3.n2 GNDA 2.2358f
C287 net3.t12 GNDA 0.22675f
C288 net3.n3 GNDA 1.14065f
C289 net3.t10 GNDA 0.05511f
C290 net3.t21 GNDA 0.05511f
C291 net3.n4 GNDA 0.11728f
C292 net3.n5 GNDA 0.7451f
C293 net3.t5 GNDA 0.05214f
C294 net3.n6 GNDA 0.57699f
C295 net3.t0 GNDA 0.05511f
C296 net3.t11 GNDA 0.05511f
C297 net3.n7 GNDA 0.11728f
C298 net3.n8 GNDA 0.7451f
C299 net3.t2 GNDA 0.05214f
C300 net3.n9 GNDA 0.57699f
C301 net3.t1 GNDA 0.24717f
C302 net3.t8 GNDA 0.05337f
C303 net3.n10 GNDA 0.64931f
C304 net3.t9 GNDA 0.01378f
C305 net3.t6 GNDA 0.01378f
C306 net3.n11 GNDA 0.02959f
C307 net3.n12 GNDA 0.3274f
C308 net3.t3 GNDA 0.01378f
C309 net3.t7 GNDA 0.01378f
C310 net3.n13 GNDA 0.02959f
C311 net3.n14 GNDA 0.3274f
C312 net3.t4 GNDA 0.05337f
C313 net3.n15 GNDA 1.53935f
C314 net3.t13 GNDA 0.06889f
C315 net3.t14 GNDA 0.06889f
C316 net3.n16 GNDA 0.20436f
C317 net3.n17 GNDA 2.51952f
C318 net3.t15 GNDA 0.06889f
C319 net3.t16 GNDA 0.06889f
C320 net3.n18 GNDA 0.29696f
C321 net3.n19 GNDA 1.58439f
C322 net3.n20 GNDA 0.40439f
C323 net4.t8 GNDA 0.05649f
C324 net4.n0 GNDA 0.69123f
C325 net4.t18 GNDA 0.0578f
C326 net4.t9 GNDA 0.0578f
C327 net4.n1 GNDA 0.1609f
C328 net4.t20 GNDA 0.0578f
C329 net4.t0 GNDA 0.0578f
C330 net4.n2 GNDA 0.12162f
C331 net4.n3 GNDA 1.00593f
C332 net4.t4 GNDA 0.05473f
C333 net4.t5 GNDA 0.05473f
C334 net4.n4 GNDA 0.22005f
C335 net4.t19 GNDA 0.0578f
C336 net4.t21 GNDA 0.0578f
C337 net4.n5 GNDA 0.14267f
C338 net4.n6 GNDA 1.20972f
C339 net4.t1 GNDA 0.05649f
C340 net4.n7 GNDA 1.4938f
C341 net4.t2 GNDA 0.01445f
C342 net4.t3 GNDA 0.01445f
C343 net4.n8 GNDA 0.03159f
C344 net4.n9 GNDA 0.45642f
C345 net4.t6 GNDA 0.01445f
C346 net4.t7 GNDA 0.01445f
C347 net4.n10 GNDA 0.03159f
C348 net4.n11 GNDA 0.45642f
C349 net4.t10 GNDA 0.39434f
C350 net4.t11 GNDA 0.07225f
C351 net4.t12 GNDA 0.07225f
C352 net4.n12 GNDA 0.21433f
C353 net4.n13 GNDA 2.34487f
C354 net4.t13 GNDA 0.30838f
C355 net4.n14 GNDA 1.28767f
C356 net4.n15 GNDA 1.30928f
C357 net4.t14 GNDA 0.07225f
C358 net4.t15 GNDA 0.07225f
C359 net4.n16 GNDA 0.31145f
C360 net4.t16 GNDA 0.07225f
C361 net4.t17 GNDA 0.07225f
C362 net4.n17 GNDA 0.21433f
C363 net4.n18 GNDA 2.43858f
C364 net4.n19 GNDA 0.49984f
C365 net7.t32 GNDA 0.12786f
C366 net7.n0 GNDA 0.31863f
C367 net7.n1 GNDA 1.72095f
C368 net7.t54 GNDA 0.12786f
C369 net7.t26 GNDA 0.12786f
C370 net7.n2 GNDA 0.35083f
C371 net7.t27 GNDA 0.12786f
C372 net7.t55 GNDA 0.12786f
C373 net7.n3 GNDA 0.31863f
C374 net7.n4 GNDA 2.28922f
C375 net7.t56 GNDA 0.12786f
C376 net7.t28 GNDA 0.12786f
C377 net7.n5 GNDA 0.31863f
C378 net7.n6 GNDA 1.30158f
C379 net7.t29 GNDA 0.12786f
C380 net7.t57 GNDA 0.12786f
C381 net7.n7 GNDA 0.31863f
C382 net7.n8 GNDA 1.30158f
C383 net7.t58 GNDA 0.12786f
C384 net7.t30 GNDA 0.12786f
C385 net7.n9 GNDA 0.31863f
C386 net7.n10 GNDA 1.30158f
C387 net7.t31 GNDA 0.12786f
C388 net7.t59 GNDA 0.12786f
C389 net7.n11 GNDA 0.31863f
C390 net7.n12 GNDA 1.30158f
C391 net7.t0 GNDA 0.25025f
C392 net7.n13 GNDA 1.4024f
C393 net7.t4 GNDA 0.06393f
C394 net7.t2 GNDA 0.06393f
C395 net7.n14 GNDA 0.14794f
C396 net7.n15 GNDA 0.96524f
C397 net7.t3 GNDA 0.25025f
C398 net7.n16 GNDA 1.06883f
C399 net7.t63 GNDA 0.25025f
C400 net7.n17 GNDA 1.06883f
C401 net7.t62 GNDA 0.06393f
C402 net7.t61 GNDA 0.06393f
C403 net7.n18 GNDA 0.14794f
C404 net7.n19 GNDA 1.66305f
C405 net7.t1 GNDA 0.26149f
C406 net7.t33 GNDA 0.12786f
C407 net7.t5 GNDA 0.12786f
C408 net7.n20 GNDA 0.35083f
C409 net7.t6 GNDA 0.12786f
C410 net7.t34 GNDA 0.12786f
C411 net7.n21 GNDA 0.31863f
C412 net7.n22 GNDA 2.28922f
C413 net7.t35 GNDA 0.12786f
C414 net7.t7 GNDA 0.12786f
C415 net7.n23 GNDA 0.31863f
C416 net7.n24 GNDA 1.30158f
C417 net7.t8 GNDA 0.12786f
C418 net7.t36 GNDA 0.12786f
C419 net7.n25 GNDA 0.31863f
C420 net7.n26 GNDA 1.30158f
C421 net7.t37 GNDA 0.12786f
C422 net7.t9 GNDA 0.12786f
C423 net7.n27 GNDA 0.31863f
C424 net7.n28 GNDA 1.30158f
C425 net7.t10 GNDA 0.12786f
C426 net7.t38 GNDA 0.12786f
C427 net7.n29 GNDA 0.31863f
C428 net7.n30 GNDA 1.30158f
C429 net7.t39 GNDA 0.12786f
C430 net7.t11 GNDA 0.12786f
C431 net7.n31 GNDA 0.31863f
C432 net7.n32 GNDA 1.72095f
C433 net7.n33 GNDA 3.20212f
C434 net7.t12 GNDA 0.12786f
C435 net7.t40 GNDA 0.12786f
C436 net7.n34 GNDA 0.35083f
C437 net7.t41 GNDA 0.12786f
C438 net7.t13 GNDA 0.12786f
C439 net7.n35 GNDA 0.31863f
C440 net7.n36 GNDA 2.28922f
C441 net7.t14 GNDA 0.12786f
C442 net7.t42 GNDA 0.12786f
C443 net7.n37 GNDA 0.31863f
C444 net7.n38 GNDA 1.30158f
C445 net7.t43 GNDA 0.12786f
C446 net7.t15 GNDA 0.12786f
C447 net7.n39 GNDA 0.31863f
C448 net7.n40 GNDA 1.30158f
C449 net7.t16 GNDA 0.12786f
C450 net7.t44 GNDA 0.12786f
C451 net7.n41 GNDA 0.31863f
C452 net7.n42 GNDA 1.30158f
C453 net7.t45 GNDA 0.12786f
C454 net7.t17 GNDA 0.12786f
C455 net7.n43 GNDA 0.31863f
C456 net7.n44 GNDA 1.30158f
C457 net7.t18 GNDA 0.12786f
C458 net7.t46 GNDA 0.12786f
C459 net7.n45 GNDA 0.31863f
C460 net7.n46 GNDA 1.72095f
C461 net7.n47 GNDA 1.05741f
C462 net7.t19 GNDA 0.12786f
C463 net7.t47 GNDA 0.12786f
C464 net7.n48 GNDA 0.35083f
C465 net7.t48 GNDA 0.12786f
C466 net7.t20 GNDA 0.12786f
C467 net7.n49 GNDA 0.31863f
C468 net7.n50 GNDA 2.28922f
C469 net7.t21 GNDA 0.12786f
C470 net7.t49 GNDA 0.12786f
C471 net7.n51 GNDA 0.31863f
C472 net7.n52 GNDA 1.30158f
C473 net7.t50 GNDA 0.12786f
C474 net7.t22 GNDA 0.12786f
C475 net7.n53 GNDA 0.31863f
C476 net7.n54 GNDA 1.30158f
C477 net7.t23 GNDA 0.12786f
C478 net7.t51 GNDA 0.12786f
C479 net7.n55 GNDA 0.31863f
C480 net7.n56 GNDA 1.30158f
C481 net7.t52 GNDA 0.12786f
C482 net7.t24 GNDA 0.12786f
C483 net7.n57 GNDA 0.31863f
C484 net7.n58 GNDA 1.30158f
C485 net7.t25 GNDA 0.12786f
C486 net7.t53 GNDA 0.12786f
C487 net7.n59 GNDA 0.31863f
C488 net7.n60 GNDA 1.72095f
C489 net7.n61 GNDA 1.05741f
C490 net7.n62 GNDA 0.65708f
C491 net7.t60 GNDA 0.12786f
C492 VBN_CASC.t2 GNDA 0.0467f
C493 VBN_CASC.n0 GNDA 0.20397f
C494 VBN_CASC.t0 GNDA 0.42943f
C495 VBN_CASC.t3 GNDA 0.24394f
C496 VBN_CASC.n1 GNDA 8.02596f
C497 VBN_CASC.n2 GNDA 2.56836f
C498 VBN_CASC.t16 GNDA 0.15423f
C499 VBN_CASC.t15 GNDA 0.12851f
C500 VBN_CASC.n3 GNDA 0.13727f
C501 VBN_CASC.t14 GNDA 0.12851f
C502 VBN_CASC.n4 GNDA 0.086f
C503 VBN_CASC.t13 GNDA 0.12851f
C504 VBN_CASC.n5 GNDA 0.086f
C505 VBN_CASC.t12 GNDA 0.12851f
C506 VBN_CASC.n6 GNDA 0.086f
C507 VBN_CASC.t11 GNDA 0.12851f
C508 VBN_CASC.n7 GNDA 0.11365f
C509 VBN_CASC.t10 GNDA 0.12851f
C510 VBN_CASC.n8 GNDA 0.09377f
C511 VBN_CASC.t9 GNDA 0.12851f
C512 VBN_CASC.n9 GNDA 0.06363f
C513 VBN_CASC.t8 GNDA 0.12851f
C514 VBN_CASC.n10 GNDA 0.06363f
C515 VBN_CASC.t7 GNDA 0.12851f
C516 VBN_CASC.n11 GNDA 0.06363f
C517 VBN_CASC.t6 GNDA 0.12851f
C518 VBN_CASC.n12 GNDA 0.06363f
C519 VBN_CASC.t5 GNDA 0.12851f
C520 VBN_CASC.n13 GNDA 0.06363f
C521 VBN_CASC.t4 GNDA 0.12851f
C522 VBN_CASC.n14 GNDA 0.06363f
C523 VBN_CASC.t1 GNDA 0.12851f
C524 VBN_CASC.n15 GNDA 0.0703f
C525 VBP_TOP.t0 GNDA 0.03559f
C526 VBP_TOP.n0 GNDA 0.35099f
C527 VBP_TOP.t1 GNDA 0.18838f
C528 VBP_TOP.t2 GNDA 0.18838f
C529 VBP_TOP.n1 GNDA 0.95734f
C530 VBP_TOP.t3 GNDA 0.18838f
C531 VBP_TOP.t4 GNDA 0.18838f
C532 VBP_TOP.n2 GNDA 0.84609f
C533 VBP_TOP.n3 GNDA 1.52845f
C534 VBP_TOP.t5 GNDA 0.18838f
C535 VBP_TOP.t6 GNDA 0.18838f
C536 VBP_TOP.n4 GNDA 0.84609f
C537 VBP_TOP.n5 GNDA 2.45359f
C538 VBP_TOP.t7 GNDA 0.18838f
C539 VBP_TOP.t8 GNDA 0.18838f
C540 VBP_TOP.n6 GNDA 1.08263f
C541 VBP_TOP.n7 GNDA 1.05043f
C542 VBP_TOP.n8 GNDA 2.17747f
C543 VBP_TOP.t9 GNDA 0.18838f
C544 VBP_TOP.t10 GNDA 0.18838f
C545 VBP_TOP.n9 GNDA 0.95734f
C546 VBP_TOP.t11 GNDA 0.18838f
C547 VBP_TOP.t12 GNDA 0.18838f
C548 VBP_TOP.n10 GNDA 0.84609f
C549 VBP_TOP.n11 GNDA 1.52845f
C550 VBP_TOP.t13 GNDA 0.18838f
C551 VBP_TOP.t14 GNDA 0.18838f
C552 VBP_TOP.n12 GNDA 0.84609f
C553 VBP_TOP.n13 GNDA 2.45359f
C554 VBP_TOP.t15 GNDA 0.18838f
C555 VBP_TOP.t16 GNDA 0.18838f
C556 VBP_TOP.n14 GNDA 1.08263f
C557 VBP_TOP.n15 GNDA 1.20215f
C558 VBP_TOP.n16 GNDA 0.13889f
C559 VBP_TOP.t18 GNDA 0.13626f
C560 VBP_TOP.t28 GNDA 1.23534f
C561 VBP_TOP.t27 GNDA 1.0046f
C562 VBP_TOP.n17 GNDA 0.4329f
C563 VBP_TOP.t17 GNDA 1.0046f
C564 VBP_TOP.n18 GNDA 0.2951f
C565 VBP_TOP.t26 GNDA 1.0046f
C566 VBP_TOP.n19 GNDA 0.33342f
C567 VBP_TOP.t25 GNDA 1.0046f
C568 VBP_TOP.n20 GNDA 0.33342f
C569 VBP_TOP.t24 GNDA 1.0046f
C570 VBP_TOP.n21 GNDA 0.32039f
C571 VBP_TOP.t23 GNDA 1.0046f
C572 VBP_TOP.n22 GNDA 0.32039f
C573 VBP_TOP.t22 GNDA 1.0046f
C574 VBP_TOP.n23 GNDA 0.32039f
C575 VBP_TOP.t21 GNDA 1.0046f
C576 VBP_TOP.n24 GNDA 0.32039f
C577 VBP_TOP.t20 GNDA 1.0046f
C578 VBP_TOP.n25 GNDA 0.40364f
C579 VBP_TOP.t19 GNDA 1.23534f
C580 VBP_TOP.n26 GNDA 0.13241f
C581 VBP_CASC.t0 GNDA 0.08045f
C582 VBP_CASC.n0 GNDA 1.88702f
C583 VBP_CASC.t3 GNDA 0.2639f
C584 VBP_CASC.t2 GNDA 0.0681f
C585 VBP_CASC.t21 GNDA 0.2041f
C586 VBP_CASC.t20 GNDA 0.18507f
C587 VBP_CASC.n1 GNDA 0.16386f
C588 VBP_CASC.t19 GNDA 0.18507f
C589 VBP_CASC.n2 GNDA 0.09765f
C590 VBP_CASC.t18 GNDA 0.18507f
C591 VBP_CASC.n3 GNDA 0.1216f
C592 VBP_CASC.t17 GNDA 0.18507f
C593 VBP_CASC.n4 GNDA 0.1216f
C594 VBP_CASC.t16 GNDA 0.18507f
C595 VBP_CASC.n5 GNDA 0.09765f
C596 VBP_CASC.t15 GNDA 0.18507f
C597 VBP_CASC.n6 GNDA 0.09765f
C598 VBP_CASC.t14 GNDA 0.18507f
C599 VBP_CASC.n7 GNDA 0.1216f
C600 VBP_CASC.t13 GNDA 0.18507f
C601 VBP_CASC.n8 GNDA 0.1216f
C602 VBP_CASC.t12 GNDA 0.18507f
C603 VBP_CASC.n9 GNDA 0.09765f
C604 VBP_CASC.t11 GNDA 0.18507f
C605 VBP_CASC.n10 GNDA 0.09765f
C606 VBP_CASC.t10 GNDA 0.18507f
C607 VBP_CASC.n11 GNDA 0.1216f
C608 VBP_CASC.t9 GNDA 0.18507f
C609 VBP_CASC.n12 GNDA 0.1216f
C610 VBP_CASC.t8 GNDA 0.18507f
C611 VBP_CASC.n13 GNDA 0.09765f
C612 VBP_CASC.t7 GNDA 0.18507f
C613 VBP_CASC.n14 GNDA 0.09765f
C614 VBP_CASC.t6 GNDA 0.18507f
C615 VBP_CASC.n15 GNDA 0.13572f
C616 VBP_CASC.t5 GNDA 0.18507f
C617 VBP_CASC.n16 GNDA 0.13229f
C618 VBP_CASC.t4 GNDA 0.18507f
C619 VBP_CASC.n17 GNDA 0.0908f
C620 VBP_CASC.t1 GNDA 0.18507f
C621 VBP_CASC.n18 GNDA 0.095f
C622 VBP_CASC.n19 GNDA 0.06844f
C623 VBP_CASC.n20 GNDA 7.70654f
C624 a_5739_8229.t0 GNDA 0.00598f
C625 a_5739_8229.t1 GNDA 0.00598f
C626 a_5881_8229.t0 GNDA 0.00603f
C627 a_5881_8229.t1 GNDA 0.00603f
C628 net8.t1 GNDA 0.02078f
C629 net8.n0 GNDA 0.06331f
C630 net8.t2 GNDA 0.08699f
C631 net8.t3 GNDA 0.04337f
C632 net8.n1 GNDA 0.35202f
C633 net8.n2 GNDA 1.20961f
C634 net8.t4 GNDA 0.0977f
C635 net8.n3 GNDA 2.13994f
C636 net8.t26 GNDA 0.22255f
C637 net8.n4 GNDA 0.32933f
C638 net8.t25 GNDA 0.22255f
C639 net8.n5 GNDA 0.37839f
C640 net8.t24 GNDA 0.22255f
C641 net8.n6 GNDA 0.37839f
C642 net8.t23 GNDA 0.22255f
C643 net8.n7 GNDA 0.34607f
C644 net8.t22 GNDA 0.22255f
C645 net8.n8 GNDA 0.34607f
C646 net8.t21 GNDA 0.22255f
C647 net8.n9 GNDA 0.34607f
C648 net8.t20 GNDA 0.22255f
C649 net8.n10 GNDA 0.34607f
C650 net8.t19 GNDA 0.22255f
C651 net8.n11 GNDA 0.37839f
C652 net8.t18 GNDA 0.22255f
C653 net8.n12 GNDA 0.37839f
C654 net8.t17 GNDA 0.22255f
C655 net8.n13 GNDA 0.33712f
C656 net8.t0 GNDA 0.22255f
C657 net8.n14 GNDA 0.29595f
C658 net8.t15 GNDA 0.22255f
C659 net8.t14 GNDA 0.22255f
C660 net8.t13 GNDA 0.22255f
C661 net8.t12 GNDA 0.22255f
C662 net8.t11 GNDA 0.22255f
C663 net8.t10 GNDA 0.22255f
C664 net8.t9 GNDA 0.22255f
C665 net8.t8 GNDA 0.22255f
C666 net8.t7 GNDA 0.22255f
C667 net8.t6 GNDA 0.22255f
C668 net8.t5 GNDA 0.22255f
C669 net8.t16 GNDA 0.29399f
C670 net8.n15 GNDA 0.1954f
C671 VSTRP_IP.t6 GNDA 0.06452f
C672 VSTRP_IP.t0 GNDA 0.2858f
C673 VSTRP_IP.t7 GNDA 0.06657f
C674 VSTRP_IP.t3 GNDA 0.06657f
C675 VSTRP_IP.n0 GNDA 0.16602f
C676 VSTRP_IP.n1 GNDA 2.09077f
C677 VSTRP_IP.t1 GNDA 0.06657f
C678 VSTRP_IP.t2 GNDA 0.06657f
C679 VSTRP_IP.n2 GNDA 0.16602f
C680 VSTRP_IP.n3 GNDA 1.1854f
C681 VSTRP_IP.t5 GNDA 0.06657f
C682 VSTRP_IP.t4 GNDA 0.06657f
C683 VSTRP_IP.n4 GNDA 0.16602f
C684 VSTRP_IP.n5 GNDA 1.32279f
C685 VSTRP_IP.t9 GNDA 0.08793f
C686 VSTRP_IP.t8 GNDA 0.08619f
C687 VSTRP_IP.n6 GNDA 0.72183f
C688 VSTRP_IP.n7 GNDA 0.84515f
C689 net14.t0 GNDA 0.16185f
C690 net14.t1 GNDA 0.15935f
C691 net14.n0 GNDA 0.99409f
C692 net14.n1 GNDA 0.64359f
C693 net14.t3 GNDA 0.1154f
C694 net14.t2 GNDA 0.11367f
C695 net14.n2 GNDA 0.98511f
C696 EN_B.t0 GNDA 0.05679f
C697 EN_B.t1 GNDA 0.06086f
C698 EN_B.n0 GNDA 1.09639f
C699 EN_B.t5 GNDA 0.04886f
C700 EN_B.t4 GNDA 0.30234f
C701 EN_B.t3 GNDA 0.49053f
C702 EN_B.n1 GNDA 0.21498f
C703 EN_B.n2 GNDA 0.75648f
C704 EN_B.t2 GNDA 1.34217f
C705 EN_B.n3 GNDA 1.26246f
C706 EN_B.n4 GNDA 0.38922f
C707 VSTRP_OUT.t0 GNDA 0.12096f
C708 VSTRP_OUT.t2 GNDA 0.12102f
C709 VSTRP_OUT.n0 GNDA 0.74378f
C710 VSTRP_OUT.n1 GNDA 0.81327f
C711 VSTRP_OUT.t3 GNDA 1.77708f
C712 VSTRP_OUT.n2 GNDA 0.62435f
C713 VSTRP_OUT.t1 GNDA 0.12708f
C714 net15.t0 GNDA 0.01787f
C715 net15.t1 GNDA 0.57317f
C716 net6.t0 GNDA 0.05324f
C717 net6.n0 GNDA 1.21967f
C718 net6.t23 GNDA 0.05654f
C719 net6.t13 GNDA 0.05324f
C720 net6.n1 GNDA 1.21967f
C721 net6.t4 GNDA 0.05654f
C722 net6.n2 GNDA 0.85367f
C723 net6.t9 GNDA 0.06942f
C724 net6.t19 GNDA 0.06942f
C725 net6.n3 GNDA 0.23857f
C726 net6.t16 GNDA 0.06942f
C727 net6.t10 GNDA 0.06942f
C728 net6.n4 GNDA 0.20344f
C729 net6.n5 GNDA 1.33583f
C730 net6.t6 GNDA 0.06942f
C731 net6.t15 GNDA 0.06942f
C732 net6.n6 GNDA 0.20344f
C733 net6.n7 GNDA 1.33583f
C734 net6.t17 GNDA 0.06942f
C735 net6.t8 GNDA 0.06942f
C736 net6.n8 GNDA 0.23857f
C737 net6.n9 GNDA 0.29173f
C738 net6.t22 GNDA 0.06942f
C739 net6.t7 GNDA 0.06942f
C740 net6.n10 GNDA 0.23857f
C741 net6.t5 GNDA 0.06942f
C742 net6.t21 GNDA 0.06942f
C743 net6.n11 GNDA 0.20344f
C744 net6.n12 GNDA 1.33583f
C745 net6.t20 GNDA 0.06942f
C746 net6.t12 GNDA 0.06942f
C747 net6.n13 GNDA 0.20344f
C748 net6.n14 GNDA 1.33583f
C749 net6.t11 GNDA 0.06942f
C750 net6.t18 GNDA 0.06942f
C751 net6.n15 GNDA 0.23857f
C752 net6.n16 GNDA 0.26311f
C753 net6.n17 GNDA 2.6691f
C754 net6.t1 GNDA 0.05654f
C755 net6.t2 GNDA 0.05324f
C756 net6.n18 GNDA 1.21967f
C757 net6.t3 GNDA 0.05324f
C758 net6.n19 GNDA 1.21967f
C759 net6.t14 GNDA 0.05654f
C760 net6.n20 GNDA 0.85367f
C761 net6.n21 GNDA 0.20604f
C762 net6.n22 GNDA 2.363f
C763 a_16520_7473.t0 GNDA 0.30445f
C764 a_16520_7473.t1 GNDA 0.22336f
C765 a_8458_6199.t1 GNDA 0.19794f
C766 a_8458_6199.t0 GNDA 0.19793f
C767 net1.t0 GNDA 0.01431f
C768 net1.n0 GNDA 0.03494f
C769 net1.n1 GNDA 2.70686f
C770 net1.t3 GNDA 0.06828f
C771 net1.t27 GNDA 0.47444f
C772 net1.n2 GNDA 1.46619f
C773 net1.t28 GNDA 0.11446f
C774 net1.t19 GNDA 0.11446f
C775 net1.n3 GNDA 0.28908f
C776 net1.n4 GNDA 1.70367f
C777 net1.t10 GNDA 0.11446f
C778 net1.t12 GNDA 0.11446f
C779 net1.n5 GNDA 0.28908f
C780 net1.n6 GNDA 2.81226f
C781 net1.t11 GNDA 0.11446f
C782 net1.t34 GNDA 0.11446f
C783 net1.n7 GNDA 0.36079f
C784 net1.t17 GNDA 0.11446f
C785 net1.t33 GNDA 0.11446f
C786 net1.n8 GNDA 0.28908f
C787 net1.n9 GNDA 1.76133f
C788 net1.t31 GNDA 0.11446f
C789 net1.t30 GNDA 0.11446f
C790 net1.n10 GNDA 0.28908f
C791 net1.n11 GNDA 1.70367f
C792 net1.t25 GNDA 0.11446f
C793 net1.t14 GNDA 0.11446f
C794 net1.n12 GNDA 0.28908f
C795 net1.n13 GNDA 2.86077f
C796 net1.t22 GNDA 0.54121f
C797 net1.n14 GNDA 1.30367f
C798 net1.t18 GNDA 0.11446f
C799 net1.t7 GNDA 0.11446f
C800 net1.n15 GNDA 0.28908f
C801 net1.n16 GNDA 1.76133f
C802 net1.t21 GNDA 0.11446f
C803 net1.t16 GNDA 0.11446f
C804 net1.n17 GNDA 0.28908f
C805 net1.n18 GNDA 1.70367f
C806 net1.t24 GNDA 0.11446f
C807 net1.t9 GNDA 0.11446f
C808 net1.n19 GNDA 0.28908f
C809 net1.n20 GNDA 2.86077f
C810 net1.t8 GNDA 0.54121f
C811 net1.n21 GNDA 0.92099f
C812 net1.t29 GNDA 0.47444f
C813 net1.n22 GNDA 1.41388f
C814 net1.t15 GNDA 0.11446f
C815 net1.t26 GNDA 0.11446f
C816 net1.n23 GNDA 0.28908f
C817 net1.n24 GNDA 1.70367f
C818 net1.t23 GNDA 0.11446f
C819 net1.t13 GNDA 0.11446f
C820 net1.n25 GNDA 0.28908f
C821 net1.n26 GNDA 2.81226f
C822 net1.t20 GNDA 0.11446f
C823 net1.t32 GNDA 0.11446f
C824 net1.n27 GNDA 0.36079f
C825 net1.n28 GNDA 0.80561f
C826 net1.t2 GNDA 0.05623f
C827 net1.n29 GNDA 1.5841f
C828 net1.t5 GNDA 0.05623f
C829 net1.n30 GNDA 0.90409f
C830 net1.t6 GNDA 0.05753f
C831 net1.n31 GNDA 1.15369f
C832 net1.t35 GNDA 0.05623f
C833 net1.n32 GNDA 2.92761f
C834 net1.t1 GNDA 0.01431f
C835 net1.t4 GNDA 0.01431f
C836 net1.n33 GNDA 0.0591f
C837 net1.n34 GNDA 0.82463f
C838 net1.n35 GNDA 0.92251f
C839 net1.t36 GNDA 0.01431f
C840 net2.t0 GNDA 0.01444f
C841 net2.n0 GNDA 0.06244f
C842 net2.t35 GNDA 0.05821f
C843 net2.n1 GNDA 3.16549f
C844 net2.t20 GNDA 0.11553f
C845 net2.t12 GNDA 0.11553f
C846 net2.n2 GNDA 0.36417f
C847 net2.t16 GNDA 0.11553f
C848 net2.t23 GNDA 0.11553f
C849 net2.n3 GNDA 0.29179f
C850 net2.n4 GNDA 2.83858f
C851 net2.t25 GNDA 0.11553f
C852 net2.t27 GNDA 0.11553f
C853 net2.n5 GNDA 0.29179f
C854 net2.n6 GNDA 1.71961f
C855 net2.t19 GNDA 0.47888f
C856 net2.n7 GNDA 1.6001f
C857 net2.t21 GNDA 0.54627f
C858 net2.t7 GNDA 0.11553f
C859 net2.t33 GNDA 0.11553f
C860 net2.n8 GNDA 0.29179f
C861 net2.n9 GNDA 2.88754f
C862 net2.t30 GNDA 0.11553f
C863 net2.t14 GNDA 0.11553f
C864 net2.n10 GNDA 0.29179f
C865 net2.n11 GNDA 1.71961f
C866 net2.t9 GNDA 0.11553f
C867 net2.t18 GNDA 0.11553f
C868 net2.n12 GNDA 0.29179f
C869 net2.n13 GNDA 1.87709f
C870 net2.n14 GNDA 1.40715f
C871 net2.t15 GNDA 0.54627f
C872 net2.t10 GNDA 0.11553f
C873 net2.t8 GNDA 0.11553f
C874 net2.n15 GNDA 0.29179f
C875 net2.n16 GNDA 2.88754f
C876 net2.t32 GNDA 0.11553f
C877 net2.t31 GNDA 0.11553f
C878 net2.n17 GNDA 0.29179f
C879 net2.n18 GNDA 1.71961f
C880 net2.t26 GNDA 0.11553f
C881 net2.t24 GNDA 0.11553f
C882 net2.n19 GNDA 0.29179f
C883 net2.n20 GNDA 1.87709f
C884 net2.n21 GNDA 0.98571f
C885 net2.t11 GNDA 0.11553f
C886 net2.t17 GNDA 0.11553f
C887 net2.n22 GNDA 0.36417f
C888 net2.t6 GNDA 0.11553f
C889 net2.t28 GNDA 0.11553f
C890 net2.n23 GNDA 0.29179f
C891 net2.n24 GNDA 2.83858f
C892 net2.t13 GNDA 0.11553f
C893 net2.t22 GNDA 0.11553f
C894 net2.n25 GNDA 0.29179f
C895 net2.n26 GNDA 1.71961f
C896 net2.t29 GNDA 0.47888f
C897 net2.n27 GNDA 1.54915f
C898 net2.n28 GNDA 0.95804f
C899 net2.t1 GNDA 0.01444f
C900 net2.t2 GNDA 0.01444f
C901 net2.n29 GNDA 0.03806f
C902 net2.t36 GNDA 0.05538f
C903 net2.n30 GNDA 2.27424f
C904 net2.n31 GNDA 1.34525f
C905 net2.t3 GNDA 0.07133f
C906 net2.t34 GNDA 0.01444f
C907 net2.t4 GNDA 0.01444f
C908 net2.n32 GNDA 0.03696f
C909 net2.n33 GNDA 2.93847f
C910 net2.n34 GNDA 1.09605f
C911 net2.n35 GNDA 0.99291f
C912 net2.t5 GNDA 0.01444f
C913 net12.t0 GNDA 1.75557f
C914 net12.t14 GNDA 1.03021f
C915 net12.t6 GNDA 0.14535f
C916 net12.t1 GNDA 0.14535f
C917 net12.n0 GNDA 0.66459f
C918 net12.n1 GNDA 1.68539f
C919 net12.t4 GNDA 0.8523f
C920 net12.n2 GNDA 1.14102f
C921 net12.t10 GNDA 0.8523f
C922 net12.n3 GNDA 1.14102f
C923 net12.t2 GNDA 0.14535f
C924 net12.t3 GNDA 0.14535f
C925 net12.n4 GNDA 0.66459f
C926 net12.n5 GNDA 0.98736f
C927 net12.t5 GNDA 0.86275f
C928 net12.n6 GNDA 0.86548f
C929 net12.n7 GNDA 1.18539f
C930 net12.t8 GNDA 1.03021f
C931 net12.t9 GNDA 0.14535f
C932 net12.t11 GNDA 0.14535f
C933 net12.n8 GNDA 0.66459f
C934 net12.n9 GNDA 1.68539f
C935 net12.t13 GNDA 0.8523f
C936 net12.n10 GNDA 1.14102f
C937 net12.t15 GNDA 0.8523f
C938 net12.n11 GNDA 1.14102f
C939 net12.t7 GNDA 0.14535f
C940 net12.t16 GNDA 0.14535f
C941 net12.n12 GNDA 0.66459f
C942 net12.n13 GNDA 0.98736f
C943 net12.t12 GNDA 0.86275f
C944 net12.n14 GNDA 0.86548f
C945 net12.n15 GNDA 0.42702f
C946 a_8836_4519.t1 GNDA 0.34325f
C947 a_8836_4519.t0 GNDA 0.34302f
C948 a_9214_6199.t1 GNDA 0.33441f
C949 a_9214_6199.t0 GNDA 0.33438f
C950 a_9592_4519.t1 GNDA 0.38294f
C951 a_9592_4519.t0 GNDA 0.38268f
C952 a_9970_6199.t1 GNDA 0.39283f
C953 a_9970_6199.t0 GNDA 0.3928f
C954 a_10348_4519.t1 GNDA 0.35774f
C955 a_10348_4519.t0 GNDA 0.35749f
C956 a_10726_6199.t1 GNDA 0.19952f
C957 a_10726_6199.t0 GNDA 0.1995f
C958 a_11104_4519.t1 GNDA 0.39284f
C959 a_11104_4519.t0 GNDA 0.39257f
C960 a_11860_6329.t1 GNDA 0.24689f
C961 a_11860_6329.t0 GNDA 0.24687f
C962 a_12238_4519.t1 GNDA 0.34218f
C963 a_12238_4519.t0 GNDA 0.34194f
C964 a_12616_6329.t1 GNDA 0.3259f
C965 a_12616_6329.t0 GNDA 0.32588f
C966 a_12994_4519.t1 GNDA 0.32597f
C967 a_12994_4519.t0 GNDA 0.32575f
C968 a_13372_6329.t1 GNDA 0.32089f
C969 a_13372_6329.t0 GNDA 0.32086f
C970 a_13750_4519.t1 GNDA 0.32176f
C971 a_13750_4519.t0 GNDA 0.32154f
C972 a_14128_6329.t1 GNDA 0.33314f
C973 a_14128_6329.t0 GNDA 0.33312f
C974 a_14506_4519.t1 GNDA 0.20741f
C975 a_14506_4519.t0 GNDA 0.20727f
C976 a_15596_6577.t0 GNDA 0.04156f
C977 a_15596_6577.t1 GNDA 0.04156f
C978 a_15904_6577.t0 GNDA 0.03719f
C979 a_15904_6577.t1 GNDA 0.03719f
C980 a_16212_6577.t0 GNDA 0.03589f
C981 a_16212_6577.t1 GNDA 0.03589f
C982 a_16520_6577.t0 GNDA 0.03123f
C983 a_16520_6577.t1 GNDA 0.03123f
C984 a_15442_4519.t0 GNDA 0.03311f
C985 a_15442_4519.t1 GNDA 0.03311f
C986 a_15750_4519.t0 GNDA 0.03521f
C987 a_15750_4519.t1 GNDA 0.03521f
C988 a_16058_4519.t0 GNDA 0.03501f
C989 a_16058_4519.t1 GNDA 0.03501f
C990 a_16366_4519.t0 GNDA 0.03476f
C991 a_16366_4519.t1 GNDA 0.03476f
C992 a_16674_4519.t0 GNDA 0.03063f
C993 a_16674_4519.t1 GNDA 0.03063f
C994 a_4949_1601.t0 GNDA 0.00293f
C995 a_4949_1601.t1 GNDA 0.00293f
C996 a_5091_1601.t0 GNDA 0.00298f
C997 a_5091_1601.t1 GNDA 0.00298f
C998 a_5233_1601.t0 GNDA 0.00305f
C999 a_5233_1601.t1 GNDA 0.00305f
C1000 a_5375_1601.t0 GNDA 0.00317f
C1001 a_5375_1601.t1 GNDA 0.00317f
C1002 a_5517_1601.t0 GNDA 0.0034f
C1003 a_5517_1601.t1 GNDA 0.0034f
C1004 a_5659_1601.t0 GNDA 0.00379f
C1005 a_5659_1601.t1 GNDA 0.00379f
C1006 a_5801_1601.t0 GNDA 0.00468f
C1007 a_5801_1601.t1 GNDA 0.00468f
C1008 VDD.t79 GNDA 0.00956f
C1009 VDD.t76 GNDA 0.00956f
C1010 VDD.n0 GNDA 0.01987f
C1011 VDD.n1 GNDA 0.15843f
C1012 VDD.n2 GNDA 0.35596f
C1013 VDD.n3 GNDA 0.52392f
C1014 VDD.n4 GNDA 0.30694f
C1015 VDD.n5 GNDA 0.52238f
C1016 VDD.n6 GNDA 2.6035f
C1017 VDD.n7 GNDA 2.6035f
C1018 VDD.t67 GNDA 3.30689f
C1019 VDD.t74 GNDA 3.11097f
C1020 VDD.t73 GNDA 3.11097f
C1021 VDD.t66 GNDA 3.11097f
C1022 VDD.t65 GNDA 3.11097f
C1023 VDD.t72 GNDA 3.11097f
C1024 VDD.t71 GNDA 2.33323f
C1025 VDD.t68 GNDA 3.30689f
C1026 VDD.t61 GNDA 3.11097f
C1027 VDD.t62 GNDA 3.11097f
C1028 VDD.t69 GNDA 3.11097f
C1029 VDD.t70 GNDA 3.11097f
C1030 VDD.t63 GNDA 3.11097f
C1031 VDD.t64 GNDA 2.33323f
C1032 VDD.n8 GNDA 1.55549f
C1033 VDD.n9 GNDA 0.52238f
C1034 VDD.n10 GNDA 0.52238f
C1035 VDD.n11 GNDA 0.30641f
C1036 VDD.n12 GNDA 0.30694f
C1037 VDD.n13 GNDA 0.30641f
C1038 VDD.n14 GNDA 0.42738f
C1039 VDD.n15 GNDA 0.34357f
C1040 VDD.t96 GNDA 0.00907f
C1041 VDD.n16 GNDA 0.15631f
C1042 VDD.t50 GNDA 0.3502f
C1043 VDD.t42 GNDA 0.00956f
C1044 VDD.t40 GNDA 0.00956f
C1045 VDD.n17 GNDA 0.01987f
C1046 VDD.t1 GNDA 0.00956f
C1047 VDD.t38 GNDA 0.00956f
C1048 VDD.n18 GNDA 0.01987f
C1049 VDD.t92 GNDA 0.00956f
C1050 VDD.t105 GNDA 0.00956f
C1051 VDD.n19 GNDA 0.01987f
C1052 VDD.t29 GNDA 0.00956f
C1053 VDD.t90 GNDA 0.00956f
C1054 VDD.n20 GNDA 0.01987f
C1055 VDD.t84 GNDA 0.04054f
C1056 VDD.n21 GNDA 0.61394f
C1057 VDD.n22 GNDA 0.15479f
C1058 VDD.n23 GNDA 0.16044f
C1059 VDD.n24 GNDA 0.1504f
C1060 VDD.t51 GNDA 0.00956f
C1061 VDD.t24 GNDA 0.00956f
C1062 VDD.n25 GNDA 0.01987f
C1063 VDD.n26 GNDA 0.05658f
C1064 VDD.t82 GNDA 0.0359f
C1065 VDD.n27 GNDA 0.05236f
C1066 VDD.t81 GNDA 0.00907f
C1067 VDD.t52 GNDA 0.56634f
C1068 VDD.t117 GNDA 0.33303f
C1069 VDD.t118 GNDA 0.50779f
C1070 VDD.t119 GNDA 0.50779f
C1071 VDD.t120 GNDA 0.50779f
C1072 VDD.t121 GNDA 0.50779f
C1073 VDD.t122 GNDA 0.50779f
C1074 VDD.t123 GNDA 0.50779f
C1075 VDD.t124 GNDA 0.50779f
C1076 VDD.t125 GNDA 0.42536f
C1077 VDD.t126 GNDA 0.61245f
C1078 VDD.n28 GNDA 0.73837f
C1079 VDD.n29 GNDA 0.08794f
C1080 VDD.t107 GNDA 0.00956f
C1081 VDD.t18 GNDA 0.00956f
C1082 VDD.n30 GNDA 0.02051f
C1083 VDD.t13 GNDA 1.89247f
C1084 VDD.t6 GNDA 0.93387f
C1085 VDD.t85 GNDA 0.93387f
C1086 VDD.t53 GNDA 1.52853f
C1087 VDD.t45 GNDA 2.12731f
C1088 VDD.t35 GNDA 1.6947f
C1089 VDD.t43 GNDA 1.14537f
C1090 VDD.t83 GNDA 0.62899f
C1091 VDD.t21 GNDA 0.7416f
C1092 VDD.t19 GNDA 0.67843f
C1093 VDD.t28 GNDA 0.19639f
C1094 VDD.t98 GNDA 0.62899f
C1095 VDD.t39 GNDA 0.62899f
C1096 VDD.t111 GNDA 0.62899f
C1097 VDD.t41 GNDA 0.65371f
C1098 VDD.t80 GNDA 0.79104f
C1099 VDD.t37 GNDA 0.65371f
C1100 VDD.t59 GNDA 0.62899f
C1101 VDD.t0 GNDA 0.62899f
C1102 VDD.t33 GNDA 0.79104f
C1103 VDD.t104 GNDA 0.79104f
C1104 VDD.t17 GNDA 0.62899f
C1105 VDD.t91 GNDA 0.62899f
C1106 VDD.t106 GNDA 0.62899f
C1107 VDD.t89 GNDA 0.62899f
C1108 VDD.t26 GNDA 0.48204f
C1109 VDD.n31 GNDA 0.14265f
C1110 VDD.n32 GNDA -0.41123f
C1111 VDD.t20 GNDA 0.00956f
C1112 VDD.t27 GNDA 0.00956f
C1113 VDD.n33 GNDA 0.02051f
C1114 VDD.n34 GNDA 0.10698f
C1115 VDD.t44 GNDA 0.00956f
C1116 VDD.t22 GNDA 0.00956f
C1117 VDD.n35 GNDA 0.02051f
C1118 VDD.n36 GNDA 0.01906f
C1119 VDD.t54 GNDA 0.02853f
C1120 VDD.t14 GNDA 0.02853f
C1121 VDD.n37 GNDA 0.11141f
C1122 VDD.t7 GNDA 0.02853f
C1123 VDD.n38 GNDA 0.02178f
C1124 VDD.n39 GNDA 0.07123f
C1125 VDD.n40 GNDA 0.05016f
C1126 VDD.t86 GNDA 0.02853f
C1127 VDD.n41 GNDA 0.07123f
C1128 VDD.n42 GNDA 0.03324f
C1129 VDD.n43 GNDA 0.07849f
C1130 VDD.n44 GNDA 0.07123f
C1131 VDD.n45 GNDA 0.0447f
C1132 VDD.t36 GNDA 0.0359f
C1133 VDD.n46 GNDA 0.09749f
C1134 VDD.n47 GNDA 0.06085f
C1135 VDD.n48 GNDA 0.04894f
C1136 VDD.n49 GNDA 0.09376f
C1137 VDD.n50 GNDA 0.09022f
C1138 VDD.n51 GNDA 0.08463f
C1139 VDD.n52 GNDA 0.09376f
C1140 VDD.n53 GNDA 0.02808f
C1141 VDD.n54 GNDA 0.05465f
C1142 VDD.n55 GNDA 0.09376f
C1143 VDD.n56 GNDA 0.05633f
C1144 VDD.t34 GNDA 0.00956f
C1145 VDD.t60 GNDA 0.00956f
C1146 VDD.n57 GNDA 0.02051f
C1147 VDD.n58 GNDA 0.09376f
C1148 VDD.n59 GNDA 0.092f
C1149 VDD.n60 GNDA 0.06934f
C1150 VDD.n61 GNDA 0.0531f
C1151 VDD.n62 GNDA 0.03952f
C1152 VDD.t112 GNDA 0.00956f
C1153 VDD.t99 GNDA 0.00956f
C1154 VDD.n63 GNDA 0.02051f
C1155 VDD.n64 GNDA 0.09376f
C1156 VDD.n65 GNDA 0.03421f
C1157 VDD.n66 GNDA 0.14237f
C1158 VDD.n67 GNDA 0.08599f
C1159 VDD.t88 GNDA 0.03585f
C1160 VDD.n68 GNDA 0.21763f
C1161 VDD.n69 GNDA 0.15761f
C1162 VDD.t9 GNDA 0.00956f
C1163 VDD.t116 GNDA 0.00956f
C1164 VDD.n70 GNDA 0.01987f
C1165 VDD.t103 GNDA 0.00956f
C1166 VDD.t56 GNDA 0.00956f
C1167 VDD.n71 GNDA 0.01987f
C1168 VDD.t5 GNDA 0.00956f
C1169 VDD.t3 GNDA 0.00956f
C1170 VDD.n72 GNDA 0.01987f
C1171 VDD.t114 GNDA 0.00956f
C1172 VDD.t101 GNDA 0.00956f
C1173 VDD.n73 GNDA 0.01987f
C1174 VDD.t12 GNDA 0.00956f
C1175 VDD.t49 GNDA 0.00956f
C1176 VDD.n74 GNDA 0.01987f
C1177 VDD.n75 GNDA 0.14915f
C1178 VDD.n76 GNDA 0.14915f
C1179 VDD.n77 GNDA 0.14915f
C1180 VDD.n78 GNDA 0.14915f
C1181 VDD.n79 GNDA 0.19816f
C1182 VDD.n80 GNDA 0.19387f
C1183 VDD.n81 GNDA 0.09637f
C1184 VDD.n82 GNDA 0.18028f
C1185 VDD.n83 GNDA -0.18007f
C1186 VDD.t23 GNDA 3.35095f
C1187 VDD.t8 GNDA 3.07491f
C1188 VDD.t87 GNDA 0.62899f
C1189 VDD.t115 GNDA 0.58504f
C1190 VDD.t10 GNDA 0.31587f
C1191 VDD.t109 GNDA 0.39003f
C1192 VDD.t95 GNDA 0.31312f
C1193 VDD.t102 GNDA 0.46144f
C1194 VDD.t31 GNDA 0.56032f
C1195 VDD.t32 GNDA 0.28565f
C1196 VDD.t55 GNDA 0.21699f
C1197 VDD.t16 GNDA 0.36531f
C1198 VDD.t97 GNDA 0.48067f
C1199 VDD.t4 GNDA 0.3708f
C1200 VDD.t110 GNDA 0.32411f
C1201 VDD.t30 GNDA 0.34196f
C1202 VDD.t75 GNDA 3.53224f
C1203 VDD.t78 GNDA 1.25798f
C1204 VDD.t48 GNDA 0.97233f
C1205 VDD.t93 GNDA 0.56032f
C1206 VDD.t25 GNDA 0.28565f
C1207 VDD.t11 GNDA 0.21699f
C1208 VDD.t108 GNDA 0.36531f
C1209 VDD.t46 GNDA 0.48067f
C1210 VDD.t100 GNDA 0.3708f
C1211 VDD.t58 GNDA 0.32411f
C1212 VDD.t57 GNDA 0.43398f
C1213 VDD.t77 GNDA 0.30488f
C1214 VDD.t113 GNDA 0.21699f
C1215 VDD.t15 GNDA 0.4999f
C1216 VDD.t47 GNDA 0.4999f
C1217 VDD.t2 GNDA 0.21699f
C1218 VDD.t94 GNDA 0.17991f
C1219 VDD.n84 GNDA -0.15428f
C1220 VDD.n85 GNDA 0.3058f
C1221 VDD.n86 GNDA 0.34473f
C1222 EN.t5 GNDA 1.35684f
C1223 EN.t4 GNDA 1.30508f
C1224 EN.n0 GNDA 2.0873f
C1225 EN.t3 GNDA 0.25245f
C1226 EN.n1 GNDA 1.41828f
C1227 EN.t6 GNDA 1.30557f
C1228 EN.n2 GNDA 1.85905f
C1229 EN.t1 GNDA 0.06077f
C1230 EN.t2 GNDA 0.06061f
C1231 EN.n3 GNDA 0.56237f
C1232 EN.n4 GNDA 0.8861f
C1233 EN.t0 GNDA 0.07437f
C1234 EN.n5 GNDA 0.74635f
C1235 VOUT.t5 GNDA 0.01588f
C1236 VOUT.t6 GNDA 0.01588f
C1237 VOUT.n0 GNDA 0.03446f
C1238 VOUT.t0 GNDA 0.01588f
C1239 VOUT.t7 GNDA 0.01588f
C1240 VOUT.n1 GNDA 0.0341f
C1241 VOUT.n2 GNDA 0.7835f
C1242 VOUT.t8 GNDA 0.01588f
C1243 VOUT.t4 GNDA 0.01588f
C1244 VOUT.n3 GNDA 0.0341f
C1245 VOUT.n4 GNDA 0.45174f
C1246 VOUT.t9 GNDA 0.01588f
C1247 VOUT.t3 GNDA 0.01588f
C1248 VOUT.n5 GNDA 0.0341f
C1249 VOUT.n6 GNDA 2.69918f
C1250 VOUT.t1 GNDA 0.06521f
C1251 VOUT.t2 GNDA 0.06363f
C1252 VOUT.n7 GNDA 1.1577f
C1253 VOUT.t10 GNDA 0.06363f
C1254 VOUT.n8 GNDA 1.95697f
C1255 VOUT.n9 GNDA 6.86621f
C1256 MN_TAIL_BIAS.t1 GNDA 0.00779f
C1257 MN_TAIL_BIAS.t2 GNDA 0.00783f
C1258 MN_TAIL_BIAS.n0 GNDA 0.30026f
C1259 MN_TAIL_BIAS.t0 GNDA 0.02968f
C1260 MN_TAIL_BIAS.n1 GNDA 0.2456f
C1261 MN_TAIL_BIAS.n2 GNDA 0.5357f
C1262 MN_TAIL_BIAS.t8 GNDA 0.03709f
C1263 MN_TAIL_BIAS.t4 GNDA 0.03709f
C1264 MN_TAIL_BIAS.n3 GNDA 0.07418f
C1265 MN_TAIL_BIAS.n4 GNDA 0.23113f
C1266 MN_TAIL_BIAS.t19 GNDA 1.53631f
C1267 MN_TAIL_BIAS.t11 GNDA 1.53631f
C1268 MN_TAIL_BIAS.n5 GNDA 1.11403f
C1269 MN_TAIL_BIAS.t20 GNDA 1.53631f
C1270 MN_TAIL_BIAS.t12 GNDA 1.53631f
C1271 MN_TAIL_BIAS.n6 GNDA 1.07946f
C1272 MN_TAIL_BIAS.n7 GNDA 0.03879f
C1273 MN_TAIL_BIAS.t21 GNDA 1.53631f
C1274 MN_TAIL_BIAS.t13 GNDA 1.53631f
C1275 MN_TAIL_BIAS.n8 GNDA 1.07946f
C1276 MN_TAIL_BIAS.n9 GNDA 0.03731f
C1277 MN_TAIL_BIAS.t22 GNDA 1.53631f
C1278 MN_TAIL_BIAS.t14 GNDA 1.53631f
C1279 MN_TAIL_BIAS.n10 GNDA 1.07946f
C1280 MN_TAIL_BIAS.n11 GNDA 0.03975f
C1281 MN_TAIL_BIAS.t7 GNDA 1.53631f
C1282 MN_TAIL_BIAS.t9 GNDA 1.53631f
C1283 MN_TAIL_BIAS.n12 GNDA 1.07946f
C1284 MN_TAIL_BIAS.n13 GNDA 0.03042f
C1285 MN_TAIL_BIAS.t26 GNDA 1.53631f
C1286 MN_TAIL_BIAS.t18 GNDA 1.53631f
C1287 MN_TAIL_BIAS.n14 GNDA 1.11403f
C1288 MN_TAIL_BIAS.t25 GNDA 1.53631f
C1289 MN_TAIL_BIAS.t17 GNDA 1.53631f
C1290 MN_TAIL_BIAS.n15 GNDA 1.07946f
C1291 MN_TAIL_BIAS.n16 GNDA 0.03879f
C1292 MN_TAIL_BIAS.t24 GNDA 1.53631f
C1293 MN_TAIL_BIAS.t16 GNDA 1.53631f
C1294 MN_TAIL_BIAS.n17 GNDA 1.07946f
C1295 MN_TAIL_BIAS.n18 GNDA 0.03731f
C1296 MN_TAIL_BIAS.t23 GNDA 1.53631f
C1297 MN_TAIL_BIAS.t15 GNDA 1.53631f
C1298 MN_TAIL_BIAS.n19 GNDA 1.07946f
C1299 MN_TAIL_BIAS.n20 GNDA 0.03975f
C1300 MN_TAIL_BIAS.t3 GNDA 1.53631f
C1301 MN_TAIL_BIAS.t5 GNDA 1.53631f
C1302 MN_TAIL_BIAS.n21 GNDA 1.07946f
C1303 MN_TAIL_BIAS.n22 GNDA 0.03042f
C1304 MN_TAIL_BIAS.n23 GNDA 0.06379f
C1305 MN_TAIL_BIAS.t10 GNDA 0.03709f
C1306 MN_TAIL_BIAS.t6 GNDA 0.03709f
C1307 MN_TAIL_BIAS.n24 GNDA 0.07418f
C1308 MN_TAIL_BIAS.n25 GNDA 0.23113f
C1309 MN_TAIL_BIAS.n26 GNDA 0.26208f
C1310 VINN.t20 GNDA 1.4732f
C1311 VINN.t27 GNDA 1.25565f
C1312 VINN.n0 GNDA 0.68159f
C1313 VINN.t26 GNDA 1.25565f
C1314 VINN.n1 GNDA 0.45419f
C1315 VINN.t19 GNDA 1.25565f
C1316 VINN.n2 GNDA 0.45419f
C1317 VINN.t18 GNDA 1.25565f
C1318 VINN.n3 GNDA 0.45419f
C1319 VINN.t25 GNDA 1.25565f
C1320 VINN.n4 GNDA 0.45419f
C1321 VINN.t24 GNDA 1.25565f
C1322 VINN.n5 GNDA 0.45419f
C1323 VINN.t17 GNDA 1.25565f
C1324 VINN.n6 GNDA 0.45419f
C1325 VINN.t16 GNDA 1.25565f
C1326 VINN.n7 GNDA 0.45419f
C1327 VINN.t23 GNDA 1.25565f
C1328 VINN.n8 GNDA 0.45419f
C1329 VINN.t22 GNDA 1.25565f
C1330 VINN.n9 GNDA 0.45419f
C1331 VINN.t15 GNDA 1.25565f
C1332 VINN.n10 GNDA 0.45419f
C1333 VINN.t14 GNDA 1.25565f
C1334 VINN.n11 GNDA 0.45419f
C1335 VINN.t21 GNDA 1.25565f
C1336 VINN.n12 GNDA 0.52216f
C1337 VINN.t13 GNDA 1.4732f
C1338 VINN.t6 GNDA 1.25565f
C1339 VINN.n13 GNDA 0.68159f
C1340 VINN.t5 GNDA 1.25565f
C1341 VINN.n14 GNDA 0.45419f
C1342 VINN.t12 GNDA 1.25565f
C1343 VINN.n15 GNDA 0.45419f
C1344 VINN.t11 GNDA 1.25565f
C1345 VINN.n16 GNDA 0.45419f
C1346 VINN.t4 GNDA 1.25565f
C1347 VINN.n17 GNDA 0.45419f
C1348 VINN.t3 GNDA 1.25565f
C1349 VINN.n18 GNDA 0.45419f
C1350 VINN.t10 GNDA 1.25565f
C1351 VINN.n19 GNDA 0.45419f
C1352 VINN.t9 GNDA 1.25565f
C1353 VINN.n20 GNDA 0.45419f
C1354 VINN.t2 GNDA 1.25565f
C1355 VINN.n21 GNDA 0.45419f
C1356 VINN.t1 GNDA 1.25565f
C1357 VINN.n22 GNDA 0.45419f
C1358 VINN.t8 GNDA 1.25565f
C1359 VINN.n23 GNDA 0.45419f
C1360 VINN.t7 GNDA 1.25565f
C1361 VINN.n24 GNDA 0.45419f
C1362 VINN.t0 GNDA 1.25565f
C1363 VINN.n25 GNDA 0.52224f
C1364 VINN.n26 GNDA 0.2688f
C1365 VINN.t35 GNDA 1.10794f
C1366 VINN.t34 GNDA 0.82678f
C1367 VINN.n27 GNDA 0.35858f
C1368 VINN.t33 GNDA 0.82678f
C1369 VINN.n28 GNDA 0.32208f
C1370 VINN.t32 GNDA 0.82678f
C1371 VINN.n29 GNDA 0.36459f
C1372 VINN.t31 GNDA 1.0051f
C1373 VINN.t30 GNDA 0.82678f
C1374 VINN.n30 GNDA 0.39153f
C1375 VINN.t29 GNDA 0.82678f
C1376 VINN.n31 GNDA 0.32208f
C1377 VINN.t28 GNDA 0.82678f
C1378 VINN.n32 GNDA 0.32914f
C1379 VINN.n33 GNDA 0.31376f
C1380 VINN.n34 GNDA 1.86081f
C1381 VINP.t28 GNDA 1.07595f
C1382 VINP.t32 GNDA 0.88754f
C1383 VINP.n0 GNDA 0.54489f
C1384 VINP.t33 GNDA 0.88754f
C1385 VINP.n1 GNDA 0.37224f
C1386 VINP.t29 GNDA 0.88754f
C1387 VINP.n2 GNDA 0.37224f
C1388 VINP.t30 GNDA 0.88754f
C1389 VINP.n3 GNDA 0.37224f
C1390 VINP.t34 GNDA 0.88754f
C1391 VINP.n4 GNDA 0.37224f
C1392 VINP.t35 GNDA 0.88754f
C1393 VINP.n5 GNDA 0.37224f
C1394 VINP.t31 GNDA 0.88754f
C1395 VINP.n6 GNDA 0.40565f
C1396 VINP.t0 GNDA 1.61527f
C1397 VINP.t1 GNDA 1.34793f
C1398 VINP.n7 GNDA 0.61477f
C1399 VINP.t2 GNDA 1.34793f
C1400 VINP.n8 GNDA 0.48094f
C1401 VINP.t3 GNDA 1.34793f
C1402 VINP.n9 GNDA 0.48094f
C1403 VINP.t4 GNDA 1.34793f
C1404 VINP.n10 GNDA 0.48094f
C1405 VINP.t5 GNDA 1.34793f
C1406 VINP.n11 GNDA 0.48094f
C1407 VINP.t6 GNDA 1.34793f
C1408 VINP.n12 GNDA 0.62899f
C1409 VINP.t21 GNDA 1.61527f
C1410 VINP.t22 GNDA 1.34793f
C1411 VINP.n13 GNDA 0.61477f
C1412 VINP.t23 GNDA 1.34793f
C1413 VINP.n14 GNDA 0.48094f
C1414 VINP.t24 GNDA 1.34793f
C1415 VINP.n15 GNDA 0.48094f
C1416 VINP.t25 GNDA 1.34793f
C1417 VINP.n16 GNDA 0.48094f
C1418 VINP.t26 GNDA 1.34793f
C1419 VINP.n17 GNDA 0.48094f
C1420 VINP.t27 GNDA 1.34793f
C1421 VINP.n18 GNDA 0.62899f
C1422 VINP.t14 GNDA 1.16803f
C1423 VINP.t7 GNDA 1.16803f
C1424 VINP.n19 GNDA 1.03159f
C1425 VINP.t15 GNDA 1.16803f
C1426 VINP.t8 GNDA 1.16803f
C1427 VINP.n20 GNDA 0.89434f
C1428 VINP.n21 GNDA 0.15814f
C1429 VINP.t16 GNDA 1.16803f
C1430 VINP.t9 GNDA 1.16803f
C1431 VINP.n22 GNDA 0.89434f
C1432 VINP.n23 GNDA 0.15007f
C1433 VINP.t17 GNDA 1.16803f
C1434 VINP.t10 GNDA 1.16803f
C1435 VINP.n24 GNDA 0.89434f
C1436 VINP.n25 GNDA 0.15007f
C1437 VINP.t18 GNDA 1.16803f
C1438 VINP.t11 GNDA 1.16803f
C1439 VINP.n26 GNDA 0.89434f
C1440 VINP.n27 GNDA 0.15007f
C1441 VINP.t19 GNDA 1.16803f
C1442 VINP.t12 GNDA 1.16803f
C1443 VINP.n28 GNDA 0.89434f
C1444 VINP.n29 GNDA 0.15007f
C1445 VINP.t20 GNDA 1.16803f
C1446 VINP.t13 GNDA 1.16803f
C1447 VINP.n30 GNDA 0.89434f
C1448 VINP.n31 GNDA 0.106f
C1449 VINP.n32 GNDA 0.48338f
.ends
