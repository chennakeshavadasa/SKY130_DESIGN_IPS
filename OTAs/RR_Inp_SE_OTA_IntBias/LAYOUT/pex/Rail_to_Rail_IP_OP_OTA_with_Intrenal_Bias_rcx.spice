* NGSPICE file created from Rail_to_Rail_IP_OP_OTA_with_Intrenal_Bias.ext - technology: sky130A

.subckt Rail_to_Rail_IP_OP_OTA_with_Intrenal_Bias VDD EN VINN VOUT VINP MN_TAIL_BIAS
+ GNDA
X0 VOUT.t4 VBP_CASC.t13 net4.t4 VDD.t41 sky130_fd_pr__pfet_01v8 ad=0.0725 pd=0.79 as=0.145 ps=1.58 w=0.5 l=0.5
X1 net2.t36 net8.t10 GNDA.t105 GNDA.t34 sky130_fd_pr__nfet_01v8 ad=0.0725 pd=0.79 as=0.0725 ps=0.79 w=0.5 l=2
X2 VOUT.t3 VBP_CASC.t15 net4.t2 VDD.t31 sky130_fd_pr__pfet_01v8 ad=0.0725 pd=0.79 as=0.0725 ps=0.79 w=0.5 l=0.5
X3 EN_B.t0 EN.t1 GNDA.t83 GNDA.t82 sky130_fd_pr__nfet_01v8 ad=0.29 pd=2.58 as=0.5 ps=3 w=1 l=0.15
X4 net7.t27 VINN.t3 net2.t5 VDD.t61 sky130_fd_pr__pfet_01v8_lvt ad=0.58 pd=4.29 as=0.58 ps=4.29 w=4 l=2
X5 VBP_CASC.t2 VBP_CASC.t1 a_5881_8265.t1 VDD.t105 sky130_fd_pr__pfet_01v8 ad=0.145 pd=1.58 as=0.0525 ps=0.71 w=0.5 l=0.5
X6 VBP_TOP.t16 MN_TAIL_BIAS.t12 net12.t11 GNDA.t54 sky130_fd_pr__nfet_01v8 ad=1.45 pd=10.29 as=1.45 ps=10.29 w=10 l=4
X7 net6.t10 VINN.t30 net4.t17 GNDA.t63 sky130_fd_pr__nfet_01v8_lvt ad=0.3625 pd=2.79 as=0.3625 ps=2.79 w=2.5 l=2
X8 net1.t31 VINP.t14 net7.t44 VDD.t64 sky130_fd_pr__pfet_01v8_lvt ad=1.16 pd=8.58 as=0.58 ps=4.29 w=4 l=2
X9 GNDA.t23 net8.t11 net1.t3 GNDA.t12 sky130_fd_pr__nfet_01v8 ad=0.0725 pd=0.79 as=0.0725 ps=0.79 w=0.5 l=2
X10 MN_TAIL_BIAS.t10 EN_B.t2 GNDA.t114 GNDA.t113 sky130_fd_pr__nfet_01v8 ad=0.145 pd=1.58 as=0.145 ps=1.58 w=0.5 l=6.4
X11 MN_TAIL_BIAS.t5 MN_TAIL_BIAS.t4 GNDA.t49 GNDA.t48 sky130_fd_pr__nfet_01v8 ad=1.45 pd=10.29 as=2.9 ps=20.58 w=10 l=4
X12 a_15904_6577.t0 VDD.t123 a_15750_4519.t1 GNDA.t72 sky130_fd_pr__nfet_01v8 ad=0.145 pd=1.58 as=0.145 ps=1.58 w=0.5 l=10
X13 GNDA.t91 net8.t26 net6.t23 GNDA.t7 sky130_fd_pr__nfet_01v8 ad=0.0725 pd=0.79 as=0.145 ps=1.58 w=0.5 l=2
X14 a_15596_6577.t0 VDD.t124 a_15750_4519.t0 GNDA.t71 sky130_fd_pr__nfet_01v8 ad=0.145 pd=1.58 as=0.145 ps=1.58 w=0.5 l=10
X15 net3.t8 VBP_CASC.t6 net5.t7 VDD.t32 sky130_fd_pr__pfet_01v8 ad=0.145 pd=1.58 as=0.0725 ps=0.79 w=0.5 l=0.5
X16 VOUT.t6 VBN_CASC.t11 net2.t32 GNDA.t89 sky130_fd_pr__nfet_01v8 ad=0.145 pd=1.58 as=0.145 ps=1.58 w=0.5 l=0.5
X17 VDD.t51 net9.t0 net9.t1 VDD.t50 sky130_fd_pr__pfet_01v8 ad=0.29 pd=2.29 as=0.58 ps=4.58 w=2 l=2
X18 VDD.t114 net9.t7 net7.t63 VDD.t113 sky130_fd_pr__pfet_01v8 ad=0.29 pd=2.29 as=0.58 ps=4.58 w=2 l=2
X19 MN_TAIL_BIAS.t8 VBP_TOP.t26 VDD.t94 VDD.t93 sky130_fd_pr__pfet_01v8 ad=0.58 pd=4.58 as=0.29 ps=2.29 w=2 l=2
X20 net1.t1 net8.t8 GNDA.t5 GNDA.t4 sky130_fd_pr__nfet_01v8 ad=0.145 pd=1.58 as=0.0725 ps=0.79 w=0.5 l=2
X21 VDD.t84 net5.t17 net4.t20 VDD.t83 sky130_fd_pr__pfet_01v8 ad=0.29 pd=2.29 as=0.29 ps=2.29 w=2 l=2
X22 net14.t0 VSTRP_IP.t9 VDD.t104 VDD.t103 sky130_fd_pr__pfet_01v8 ad=0.29 pd=2.58 as=0.5 ps=3 w=1 l=0.15
X23 net4.t18 VINN.t29 net6.t8 GNDA.t64 sky130_fd_pr__nfet_01v8_lvt ad=0.3625 pd=2.79 as=0.3625 ps=2.79 w=2.5 l=2
X24 net1.t17 VINP.t24 net7.t34 VDD.t68 sky130_fd_pr__pfet_01v8_lvt ad=0.58 pd=4.29 as=0.58 ps=4.29 w=4 l=2
X25 VBP_TOP.t8 MN_TAIL_BIAS.t20 net12.t6 GNDA.t54 sky130_fd_pr__nfet_01v8 ad=1.45 pd=10.29 as=1.45 ps=10.29 w=10 l=4
X26 a_16212_6577.t1 VDD.t120 a_16366_4519.t0 GNDA.t75 sky130_fd_pr__nfet_01v8 ad=0.145 pd=1.58 as=0.145 ps=1.58 w=0.5 l=10
X27 a_11860_6329.t0 VDD.t0 GNDA.t6 sky130_fd_pr__res_xhigh_po_1p41 l=7.05
X28 a_10726_6199.t1 a_10348_4519.t1 GNDA.t87 sky130_fd_pr__res_xhigh_po_1p41 l=6.4
X29 VDD.t11 net5.t23 net3.t9 VDD.t10 sky130_fd_pr__pfet_01v8 ad=0.29 pd=2.29 as=0.58 ps=4.58 w=2 l=2
X30 net1.t36 net8.t12 GNDA.t106 GNDA.t31 sky130_fd_pr__nfet_01v8 ad=0.0725 pd=0.79 as=0.0725 ps=0.79 w=0.5 l=2
X31 net2.t27 VINN.t27 net7.t3 VDD.t58 sky130_fd_pr__pfet_01v8_lvt ad=0.58 pd=4.29 as=0.58 ps=4.29 w=4 l=2
X32 VBP_TOP.t4 MN_TAIL_BIAS.t24 net12.t10 GNDA.t46 sky130_fd_pr__nfet_01v8 ad=1.45 pd=10.29 as=1.45 ps=10.29 w=10 l=4
X33 net7.t1 net9.t4 VDD.t27 VDD.t26 sky130_fd_pr__pfet_01v8 ad=0.58 pd=4.58 as=0.29 ps=2.29 w=2 l=2
X34 net5.t0 VBP_CASC.t21 net3.t3 VDD.t30 sky130_fd_pr__pfet_01v8 ad=0.0725 pd=0.79 as=0.145 ps=1.58 w=0.5 l=0.5
X35 net6.t22 VINP.t34 net3.t15 GNDA.t63 sky130_fd_pr__nfet_01v8_lvt ad=0.3625 pd=2.79 as=0.3625 ps=2.79 w=2.5 l=2
X36 net1.t21 VINP.t16 net7.t42 VDD.t62 sky130_fd_pr__pfet_01v8_lvt ad=0.58 pd=4.29 as=0.58 ps=4.29 w=4 l=2
X37 VBN_CASC.t3 EN_B.t3 GNDA.t96 GNDA.t95 sky130_fd_pr__nfet_01v8 ad=0.29 pd=2.58 as=0.145 ps=1.29 w=1 l=2
X38 VBP_TOP.t10 MN_TAIL_BIAS.t18 net12.t9 GNDA.t44 sky130_fd_pr__nfet_01v8 ad=1.45 pd=10.29 as=2.9 ps=20.58 w=10 l=4
X39 net4.t9 net5.t14 VDD.t21 VDD.t20 sky130_fd_pr__pfet_01v8 ad=0.29 pd=2.29 as=0.29 ps=2.29 w=2 l=2
X40 net1.t16 VINP.t11 net7.t47 VDD.t60 sky130_fd_pr__pfet_01v8_lvt ad=0.58 pd=4.29 as=0.58 ps=4.29 w=4 l=2
X41 GNDA.t1 EN_B.t4 net8.t4 GNDA.t0 sky130_fd_pr__nfet_01v8 ad=0.145 pd=1.29 as=0.29 ps=2.58 w=1 l=1
X42 net7.t8 VINN.t22 net2.t4 VDD.t63 sky130_fd_pr__pfet_01v8_lvt ad=0.58 pd=4.29 as=0.58 ps=4.29 w=4 l=2
X43 net7.t39 VINP.t19 net1.t7 VDD.t59 sky130_fd_pr__pfet_01v8_lvt ad=0.58 pd=4.29 as=0.58 ps=4.29 w=4 l=2
X44 net4.t16 VINN.t31 net6.t11 GNDA.t62 sky130_fd_pr__nfet_01v8_lvt ad=0.3625 pd=2.79 as=0.3625 ps=2.79 w=2.5 l=2
X45 GNDA.t28 net8.t1 net8.t2 GNDA.t27 sky130_fd_pr__nfet_01v8 ad=0.0725 pd=0.79 as=0.145 ps=1.58 w=0.5 l=2
X46 net6.t1 net8.t17 GNDA.t11 GNDA.t10 sky130_fd_pr__nfet_01v8 ad=0.145 pd=1.58 as=0.0725 ps=0.79 w=0.5 l=2
X47 net3.t16 VINP.t33 net6.t20 GNDA.t64 sky130_fd_pr__nfet_01v8_lvt ad=0.3625 pd=2.79 as=0.3625 ps=2.79 w=2.5 l=2
X48 net12.t0 MN_TAIL_BIAS.t19 VBP_TOP.t9 GNDA.t55 sky130_fd_pr__nfet_01v8 ad=2.9 pd=20.58 as=1.45 ps=10.29 w=10 l=4
X49 GNDA.t103 net8.t13 net2.t35 GNDA.t18 sky130_fd_pr__nfet_01v8 ad=0.0725 pd=0.79 as=0.145 ps=1.58 w=0.5 l=2
X50 a_5517_1601.t0 VBN_CASC.t6 a_5375_1601.t1 GNDA.t86 sky130_fd_pr__nfet_01v8 ad=0.0525 pd=0.71 as=0.0525 ps=0.71 w=0.5 l=0.5
X51 net4.t5 VBP_CASC.t12 VOUT.t7 VDD.t91 sky130_fd_pr__pfet_01v8 ad=0.0725 pd=0.79 as=0.0725 ps=0.79 w=0.5 l=0.5
X52 a_5881_8265.t0 VBP_CASC.t4 a_5739_8265.t0 VDD.t46 sky130_fd_pr__pfet_01v8 ad=0.0525 pd=0.71 as=0.0525 ps=0.71 w=0.5 l=0.5
X53 net7.t21 VINN.t9 net2.t11 VDD.t69 sky130_fd_pr__pfet_01v8_lvt ad=0.58 pd=4.29 as=0.58 ps=4.29 w=4 l=2
X54 a_5091_1601.t1 VBN_CASC.t9 a_4949_1601.t0 GNDA.t37 sky130_fd_pr__nfet_01v8 ad=0.0525 pd=0.71 as=0.0525 ps=0.71 w=0.5 l=0.5
X55 net15.t0 a_14506_4519.t0 GNDA.t26 sky130_fd_pr__res_xhigh_po_1p41 l=7.05
X56 net4.t3 VBP_CASC.t14 VOUT.t1 VDD.t22 sky130_fd_pr__pfet_01v8 ad=0.145 pd=1.58 as=0.0725 ps=0.79 w=0.5 l=0.5
X57 net2.t8 VINN.t21 net7.t9 VDD.t64 sky130_fd_pr__pfet_01v8_lvt ad=1.16 pd=8.58 as=0.58 ps=4.29 w=4 l=2
X58 net7.t10 VINN.t20 net2.t15 VDD.t65 sky130_fd_pr__pfet_01v8_lvt ad=0.58 pd=4.29 as=1.16 ps=8.58 w=4 l=2
X59 net12.t12 MN_TAIL_BIAS.t21 VBP_TOP.t7 GNDA.t53 sky130_fd_pr__nfet_01v8 ad=1.45 pd=10.29 as=1.45 ps=10.29 w=10 l=4
X60 net6.t14 net8.t14 GNDA.t68 GNDA.t66 sky130_fd_pr__nfet_01v8 ad=0.145 pd=1.58 as=0.0725 ps=0.79 w=0.5 l=2
X61 VDD.t80 EN.t5 VBP_CASC.t3 VDD.t79 sky130_fd_pr__pfet_01v8 ad=0.58 pd=4.58 as=0.58 ps=4.58 w=2 l=2
X62 net12.t15 MN_TAIL_BIAS.t23 VBP_TOP.t5 GNDA.t47 sky130_fd_pr__nfet_01v8 ad=2.9 pd=20.58 as=1.45 ps=10.29 w=10 l=4
X63 a_5659_1601.t0 VBN_CASC.t5 a_5517_1601.t1 GNDA.t98 sky130_fd_pr__nfet_01v8 ad=0.0525 pd=0.71 as=0.0525 ps=0.71 w=0.5 l=0.5
X64 net2.t14 VINN.t19 net7.t11 VDD.t66 sky130_fd_pr__pfet_01v8_lvt ad=0.58 pd=4.29 as=0.58 ps=4.29 w=4 l=2
X65 net2.t18 VINN.t4 net7.t26 VDD.t60 sky130_fd_pr__pfet_01v8_lvt ad=0.58 pd=4.29 as=0.58 ps=4.29 w=4 l=2
X66 VDD.t102 net9.t10 net7.t61 VDD.t101 sky130_fd_pr__pfet_01v8 ad=0.29 pd=2.29 as=0.29 ps=2.29 w=2 l=2
X67 GNDA.t22 net8.t18 net6.t2 GNDA.t21 sky130_fd_pr__nfet_01v8 ad=0.0725 pd=0.79 as=0.145 ps=1.58 w=0.5 l=2
X68 net3.t2 VBP_CASC.t8 net5.t5 VDD.t49 sky130_fd_pr__pfet_01v8 ad=0.0725 pd=0.79 as=0.0725 ps=0.79 w=0.5 l=0.5
X69 net7.t16 VINN.t14 net2.t31 VDD.t71 sky130_fd_pr__pfet_01v8_lvt ad=0.58 pd=4.29 as=0.58 ps=4.29 w=4 l=2
X70 net2.t20 VINN.t8 net7.t22 VDD.t70 sky130_fd_pr__pfet_01v8_lvt ad=0.58 pd=4.29 as=0.58 ps=4.29 w=4 l=2
X71 MN_TAIL_BIAS.t3 MN_TAIL_BIAS.t2 GNDA.t56 GNDA.t48 sky130_fd_pr__nfet_01v8 ad=1.45 pd=10.29 as=2.9 ps=20.58 w=10 l=4
X72 net12.t2 MN_TAIL_BIAS.t13 VBP_TOP.t15 GNDA.t53 sky130_fd_pr__nfet_01v8 ad=1.45 pd=10.29 as=1.45 ps=10.29 w=10 l=4
X73 net3.t14 VINP.t35 net6.t15 GNDA.t62 sky130_fd_pr__nfet_01v8_lvt ad=0.3625 pd=2.79 as=0.3625 ps=2.79 w=2.5 l=2
X74 GNDA.t57 MN_TAIL_BIAS.t0 MN_TAIL_BIAS.t1 GNDA.t50 sky130_fd_pr__nfet_01v8 ad=2.9 pd=20.58 as=1.45 ps=10.29 w=10 l=4
X75 VBP_TOP.t12 MN_TAIL_BIAS.t16 net12.t8 GNDA.t46 sky130_fd_pr__nfet_01v8 ad=1.45 pd=10.29 as=1.45 ps=10.29 w=10 l=4
X76 a_5801_1601.t1 VBN_CASC.t4 a_5659_1601.t1 GNDA.t107 sky130_fd_pr__nfet_01v8 ad=0.0525 pd=0.71 as=0.0525 ps=0.71 w=0.5 l=0.5
X77 GNDA.t51 MN_TAIL_BIAS.t6 MN_TAIL_BIAS.t7 GNDA.t50 sky130_fd_pr__nfet_01v8 ad=2.9 pd=20.58 as=1.45 ps=10.29 w=10 l=4
X78 VDD.t90 net5.t15 net3.t13 VDD.t89 sky130_fd_pr__pfet_01v8 ad=0.29 pd=2.29 as=0.29 ps=2.29 w=2 l=2
X79 VDD.t88 VBP_TOP.t25 VSTRP_IP.t6 VDD.t87 sky130_fd_pr__pfet_01v8 ad=0.29 pd=2.29 as=0.58 ps=4.58 w=2 l=2
X80 VSTRP_OUT.t0 net14.t3 VDD.t35 VDD.t34 sky130_fd_pr__pfet_01v8 ad=0.29 pd=2.58 as=0.5 ps=3 w=1 l=0.15
X81 net7.t19 VINN.t11 net2.t26 VDD.t67 sky130_fd_pr__pfet_01v8_lvt ad=0.58 pd=4.29 as=0.58 ps=4.29 w=4 l=2
X82 net2.t16 VINN.t23 net7.t7 VDD.t62 sky130_fd_pr__pfet_01v8_lvt ad=0.58 pd=4.29 as=0.58 ps=4.29 w=4 l=2
X83 net7.t41 VINP.t17 net1.t25 VDD.t61 sky130_fd_pr__pfet_01v8_lvt ad=0.58 pd=4.29 as=0.58 ps=4.29 w=4 l=2
X84 a_11860_6329.t1 a_12238_4519.t1 GNDA.t88 sky130_fd_pr__res_xhigh_po_1p41 l=7.05
X85 net7.t56 VINP.t2 net1.t29 VDD.t69 sky130_fd_pr__pfet_01v8_lvt ad=0.58 pd=4.29 as=0.58 ps=4.29 w=4 l=2
X86 VDD.t29 VBP_TOP.t0 VBP_TOP.t1 VDD.t28 sky130_fd_pr__pfet_01v8 ad=0.29 pd=2.29 as=0.58 ps=4.58 w=2 l=2
X87 a_13372_6329.t0 a_12994_4519.t1 GNDA.t25 sky130_fd_pr__res_xhigh_po_1p41 l=7.05
X88 net6.t17 VINP.t29 net3.t20 GNDA.t60 sky130_fd_pr__nfet_01v8_lvt ad=0.3625 pd=2.79 as=0.3625 ps=2.79 w=2.5 l=2
X89 VBP_TOP.t2 MN_TAIL_BIAS.t26 net12.t13 GNDA.t44 sky130_fd_pr__nfet_01v8 ad=1.45 pd=10.29 as=2.9 ps=20.58 w=10 l=4
X90 VBN_CASC.t1 VBN_CASC.t0 a_5801_1601.t0 GNDA.t104 sky130_fd_pr__nfet_01v8 ad=0.145 pd=1.58 as=0.0525 ps=0.71 w=0.5 l=0.5
X91 a_5233_1601.t0 VBN_CASC.t8 a_5091_1601.t0 GNDA.t30 sky130_fd_pr__nfet_01v8 ad=0.0525 pd=0.71 as=0.0525 ps=0.71 w=0.5 l=0.5
X92 a_16520_6577.t1 VDD.t119 a_16366_4519.t1 GNDA.t76 sky130_fd_pr__nfet_01v8 ad=0.145 pd=1.58 as=0.145 ps=1.58 w=0.5 l=10
X93 net4.t8 net5.t22 VDD.t19 VDD.t18 sky130_fd_pr__pfet_01v8 ad=0.29 pd=2.29 as=0.29 ps=2.29 w=2 l=2
X94 net3.t1 VBP_CASC.t20 net5.t1 VDD.t33 sky130_fd_pr__pfet_01v8 ad=0.0725 pd=0.79 as=0.0725 ps=0.79 w=0.5 l=0.5
X95 net7.t4 VINN.t26 net2.t21 VDD.t59 sky130_fd_pr__pfet_01v8_lvt ad=0.58 pd=4.29 as=0.58 ps=4.29 w=4 l=2
X96 VBP_TOP.t6 MN_TAIL_BIAS.t22 net12.t4 GNDA.t52 sky130_fd_pr__nfet_01v8 ad=1.45 pd=10.29 as=2.9 ps=20.58 w=10 l=4
X97 VDD.t74 EN.t4 net5.t11 VDD.t39 sky130_fd_pr__pfet_01v8 ad=0.58 pd=4.58 as=0.58 ps=4.58 w=2 l=2
X98 VDD.t100 net9.t5 net7.t60 VDD.t99 sky130_fd_pr__pfet_01v8 ad=0.29 pd=2.29 as=0.29 ps=2.29 w=2 l=2
X99 VSTRP_IP.t2 VBP_TOP.t22 VDD.t25 VDD.t24 sky130_fd_pr__pfet_01v8 ad=0.29 pd=2.29 as=0.29 ps=2.29 w=2 l=2
X100 GNDA.t3 net8.t20 net1.t0 GNDA.t2 sky130_fd_pr__nfet_01v8 ad=0.0725 pd=0.79 as=0.0725 ps=0.79 w=0.5 l=2
X101 net3.t4 VBP_CASC.t18 net5.t3 VDD.t36 sky130_fd_pr__pfet_01v8 ad=0.145 pd=1.58 as=0.0725 ps=0.79 w=0.5 l=0.5
X102 VSTRP_OUT.t2 EN_B.t5 VDD.t116 VDD.t115 sky130_fd_pr__pfet_01v8 ad=0.29 pd=2.58 as=0.5 ps=3 w=1 l=0.15
X103 net1.t27 VINP.t1 net7.t57 VDD.t70 sky130_fd_pr__pfet_01v8_lvt ad=0.58 pd=4.29 as=0.58 ps=4.29 w=4 l=2
X104 a_5375_1601.t0 VBN_CASC.t7 a_5233_1601.t1 GNDA.t38 sky130_fd_pr__nfet_01v8 ad=0.0525 pd=0.71 as=0.0525 ps=0.71 w=0.5 l=0.5
X105 net3.t21 VINP.t28 net6.t16 GNDA.t61 sky130_fd_pr__nfet_01v8_lvt ad=0.725 pd=5.58 as=0.3625 ps=2.79 w=2.5 l=2
X106 net7.t31 VINP.t27 net1.t26 VDD.t65 sky130_fd_pr__pfet_01v8_lvt ad=0.58 pd=4.29 as=1.16 ps=8.58 w=4 l=2
X107 a_9214_6199.t0 a_8836_4519.t0 GNDA.t15 sky130_fd_pr__res_xhigh_po_1p41 l=6.4
X108 VOUT.t10 VBP_CASC.t11 net4.t6 VDD.t112 sky130_fd_pr__pfet_01v8 ad=0.0725 pd=0.79 as=0.0725 ps=0.79 w=0.5 l=0.5
X109 net7.t54 VINP.t4 net1.t15 VDD.t67 sky130_fd_pr__pfet_01v8_lvt ad=0.58 pd=4.29 as=0.58 ps=4.29 w=4 l=2
X110 VDD.t43 net5.t21 net4.t10 VDD.t42 sky130_fd_pr__pfet_01v8 ad=0.29 pd=2.29 as=0.29 ps=2.29 w=2 l=2
X111 net7.t62 net9.t11 VDD.t109 VDD.t108 sky130_fd_pr__pfet_01v8 ad=0.29 pd=2.29 as=0.29 ps=2.29 w=2 l=2
X112 net1.t13 VINP.t26 net7.t32 VDD.t66 sky130_fd_pr__pfet_01v8_lvt ad=0.58 pd=4.29 as=0.58 ps=4.29 w=4 l=2
X113 net6.t12 VINN.t33 net4.t14 GNDA.t60 sky130_fd_pr__nfet_01v8_lvt ad=0.3625 pd=2.79 as=0.3625 ps=2.79 w=2.5 l=2
X114 net12.t1 MN_TAIL_BIAS.t25 VBP_TOP.t3 GNDA.t45 sky130_fd_pr__nfet_01v8 ad=1.45 pd=10.29 as=1.45 ps=10.29 w=10 l=4
X115 net3.t11 net5.t12 VDD.t55 VDD.t54 sky130_fd_pr__pfet_01v8 ad=0.58 pd=4.58 as=0.29 ps=2.29 w=2 l=2
X116 net2.t13 VINN.t10 net7.t20 VDD.t68 sky130_fd_pr__pfet_01v8_lvt ad=0.58 pd=4.29 as=0.58 ps=4.29 w=4 l=2
X117 a_13372_6329.t1 a_13750_4519.t0 GNDA.t94 sky130_fd_pr__res_xhigh_po_1p41 l=7.05
X118 a_12616_6329.t0 a_12238_4519.t0 GNDA.t9 sky130_fd_pr__res_xhigh_po_1p41 l=7.05
X119 VDD.t38 VBP_TOP.t21 VSTRP_IP.t3 VDD.t37 sky130_fd_pr__pfet_01v8 ad=0.29 pd=2.29 as=0.29 ps=2.29 w=2 l=2
X120 net7.t37 VINP.t21 net1.t8 VDD.t71 sky130_fd_pr__pfet_01v8_lvt ad=0.58 pd=4.29 as=0.58 ps=4.29 w=4 l=2
X121 net1.t6 net8.t21 GNDA.t35 GNDA.t34 sky130_fd_pr__nfet_01v8 ad=0.0725 pd=0.79 as=0.0725 ps=0.79 w=0.5 l=2
X122 net12.t3 MN_TAIL_BIAS.t11 VBP_TOP.t17 GNDA.t55 sky130_fd_pr__nfet_01v8 ad=2.9 pd=20.58 as=1.45 ps=10.29 w=10 l=4
X123 EN_B.t1 EN.t2 VDD.t76 VDD.t75 sky130_fd_pr__pfet_01v8 ad=0.29 pd=2.58 as=0.5 ps=3 w=1 l=0.15
X124 net4.t21 net5.t18 VDD.t107 VDD.t106 sky130_fd_pr__pfet_01v8 ad=0.29 pd=2.29 as=0.29 ps=2.29 w=2 l=2
X125 net1.t24 VINP.t13 net7.t45 VDD.t58 sky130_fd_pr__pfet_01v8_lvt ad=0.58 pd=4.29 as=0.58 ps=4.29 w=4 l=2
X126 net7.t6 VINN.t24 net2.t29 VDD.t61 sky130_fd_pr__pfet_01v8_lvt ad=0.58 pd=4.29 as=0.58 ps=4.29 w=4 l=2
X127 GNDA.t13 net8.t22 net2.t0 GNDA.t12 sky130_fd_pr__nfet_01v8 ad=0.0725 pd=0.79 as=0.0725 ps=0.79 w=0.5 l=2
X128 net4.t15 VINN.t32 net6.t7 GNDA.t61 sky130_fd_pr__nfet_01v8_lvt ad=0.725 pd=5.58 as=0.3625 ps=2.79 w=2.5 l=2
X129 net1.t4 VBN_CASC.t16 net5.t8 GNDA.t24 sky130_fd_pr__nfet_01v8 ad=0.145 pd=1.58 as=0.145 ps=1.58 w=0.5 l=0.5
X130 VDD.t111 VBP_TOP.t19 VSTRP_IP.t7 VDD.t110 sky130_fd_pr__pfet_01v8 ad=0.58 pd=4.58 as=0.29 ps=2.29 w=2 l=2
X131 net7.t50 VINP.t8 net1.t32 VDD.t63 sky130_fd_pr__pfet_01v8_lvt ad=0.58 pd=4.29 as=0.58 ps=4.29 w=4 l=2
X132 net2.t3 net8.t19 GNDA.t42 GNDA.t4 sky130_fd_pr__nfet_01v8 ad=0.145 pd=1.58 as=0.0725 ps=0.79 w=0.5 l=2
X133 VBN_CASC.t2 net9.t8 VDD.t9 VDD.t8 sky130_fd_pr__pfet_01v8 ad=0.58 pd=4.58 as=0.29 ps=2.29 w=2 l=2
X134 VOUT.t2 VBP_CASC.t17 net4.t0 VDD.t23 sky130_fd_pr__pfet_01v8 ad=0.0725 pd=0.79 as=0.145 ps=1.58 w=0.5 l=0.5
X135 VBP_TOP.t14 MN_TAIL_BIAS.t14 net12.t14 GNDA.t52 sky130_fd_pr__nfet_01v8 ad=1.45 pd=10.29 as=2.9 ps=20.58 w=10 l=4
X136 GNDA.t8 net8.t15 net6.t0 GNDA.t7 sky130_fd_pr__nfet_01v8 ad=0.0725 pd=0.79 as=0.145 ps=1.58 w=0.5 l=2
X137 VSTRP_IP.t5 VDD.t126 a_15442_4519.t1 GNDA.t69 sky130_fd_pr__nfet_01v8 ad=0.145 pd=1.58 as=0.145 ps=1.58 w=0.5 l=10
X138 net6.t6 VINN.t28 net4.t19 GNDA.t65 sky130_fd_pr__nfet_01v8_lvt ad=0.3625 pd=2.79 as=0.3625 ps=2.79 w=2.5 l=2
X139 GNDA.t79 VDD.t117 a_16674_4519.t0 GNDA.t78 sky130_fd_pr__nfet_01v8 ad=0.145 pd=1.58 as=0.145 ps=1.58 w=0.5 l=10
X140 net5.t2 VBP_CASC.t19 net3.t5 VDD.t95 sky130_fd_pr__pfet_01v8 ad=0.0725 pd=0.79 as=0.0725 ps=0.79 w=0.5 l=0.5
X141 net1.t23 VINP.t18 net7.t40 VDD.t60 sky130_fd_pr__pfet_01v8_lvt ad=0.58 pd=4.29 as=0.58 ps=4.29 w=4 l=2
X142 a_16520_6577.t0 VDD.t118 a_16674_4519.t1 GNDA.t77 sky130_fd_pr__nfet_01v8 ad=0.145 pd=1.58 as=0.145 ps=1.58 w=0.5 l=10
X143 a_10726_6199.t0 a_11104_4519.t0 GNDA.t20 sky130_fd_pr__res_xhigh_po_1p41 l=6.4
X144 net1.t9 VINP.t3 net7.t55 VDD.t68 sky130_fd_pr__pfet_01v8_lvt ad=0.58 pd=4.29 as=0.58 ps=4.29 w=4 l=2
X145 net14.t1 VSTRP_IP.t8 GNDA.t100 GNDA.t99 sky130_fd_pr__nfet_01v8 ad=0.29 pd=2.58 as=0.5 ps=3 w=1 l=0.15
X146 net1.t28 VINP.t7 net7.t51 VDD.t64 sky130_fd_pr__pfet_01v8_lvt ad=1.16 pd=8.58 as=0.58 ps=4.29 w=4 l=2
X147 net12.t7 MN_TAIL_BIAS.t17 VBP_TOP.t11 GNDA.t45 sky130_fd_pr__nfet_01v8 ad=1.45 pd=10.29 as=1.45 ps=10.29 w=10 l=4
X148 net2.t2 net8.t23 GNDA.t32 GNDA.t31 sky130_fd_pr__nfet_01v8 ad=0.0725 pd=0.79 as=0.0725 ps=0.79 w=0.5 l=2
X149 a_15904_6577.t1 VDD.t122 a_16058_4519.t0 GNDA.t73 sky130_fd_pr__nfet_01v8 ad=0.145 pd=1.58 as=0.145 ps=1.58 w=0.5 l=10
X150 net8.t0 VBP_TOP.t27 VDD.t3 VDD.t2 sky130_fd_pr__pfet_01v8 ad=0.58 pd=4.58 as=0.29 ps=2.29 w=2 l=2
X151 net2.t25 VINN.t6 net7.t24 VDD.t58 sky130_fd_pr__pfet_01v8_lvt ad=0.58 pd=4.29 as=0.58 ps=4.29 w=4 l=2
X152 net9.t3 EN.t6 VDD.t82 VDD.t81 sky130_fd_pr__pfet_01v8 ad=0.58 pd=4.58 as=0.58 ps=4.58 w=2 l=2
X153 net4.t7 VBP_CASC.t10 VOUT.t8 VDD.t92 sky130_fd_pr__pfet_01v8 ad=0.145 pd=1.58 as=0.0725 ps=0.79 w=0.5 l=0.5
X154 net7.t14 VINN.t16 net2.t30 VDD.t69 sky130_fd_pr__pfet_01v8_lvt ad=0.58 pd=4.29 as=0.58 ps=4.29 w=4 l=2
X155 net7.t29 VINN.t1 net2.t22 VDD.t63 sky130_fd_pr__pfet_01v8_lvt ad=0.58 pd=4.29 as=0.58 ps=4.29 w=4 l=2
X156 VBP_TOP.t18 EN.t3 VDD.t78 VDD.t77 sky130_fd_pr__pfet_01v8 ad=0.145 pd=1.58 as=0.145 ps=1.58 w=0.5 l=1
X157 net5.t9 VBN_CASC.t13 net1.t5 GNDA.t33 sky130_fd_pr__nfet_01v8 ad=0.0725 pd=0.79 as=0.145 ps=1.58 w=0.5 l=0.5
X158 GNDA.t19 net8.t24 net1.t2 GNDA.t18 sky130_fd_pr__nfet_01v8 ad=0.0725 pd=0.79 as=0.145 ps=1.58 w=0.5 l=2
X159 a_14128_6329.t1 a_13750_4519.t1 GNDA.t111 sky130_fd_pr__res_xhigh_po_1p41 l=7.05
X160 net6.t18 VINP.t32 net3.t17 GNDA.t65 sky130_fd_pr__nfet_01v8_lvt ad=0.3625 pd=2.79 as=0.3625 ps=2.79 w=2.5 l=2
X161 net6.t19 VINP.t31 net3.t18 GNDA.t58 sky130_fd_pr__nfet_01v8_lvt ad=0.3625 pd=2.79 as=0.725 ps=5.58 w=2.5 l=2
X162 net2.t1 VBN_CASC.t15 VOUT.t0 GNDA.t14 sky130_fd_pr__nfet_01v8 ad=0.0725 pd=0.79 as=0.145 ps=1.58 w=0.5 l=0.5
X163 VDD.t40 net9.t12 net7.t2 VDD.t39 sky130_fd_pr__pfet_01v8 ad=0.29 pd=2.29 as=0.58 ps=4.58 w=2 l=2
X164 VSTRP_IP.t1 VBP_TOP.t20 VDD.t17 VDD.t16 sky130_fd_pr__pfet_01v8 ad=0.29 pd=2.29 as=0.29 ps=2.29 w=2 l=2
X165 net1.t34 VINP.t9 net7.t49 VDD.t62 sky130_fd_pr__pfet_01v8_lvt ad=0.58 pd=4.29 as=0.58 ps=4.29 w=4 l=2
X166 GNDA.t112 net8.t5 VBP_CASC.t0 GNDA.t27 sky130_fd_pr__nfet_01v8 ad=0.145 pd=1.58 as=0.145 ps=1.58 w=0.5 l=2
X167 net6.t3 net8.t6 GNDA.t36 GNDA.t10 sky130_fd_pr__nfet_01v8 ad=0.145 pd=1.58 as=0.0725 ps=0.79 w=0.5 l=2
X168 net2.t7 VINN.t15 net7.t15 VDD.t70 sky130_fd_pr__pfet_01v8_lvt ad=0.58 pd=4.29 as=0.58 ps=4.29 w=4 l=2
X169 net6.t13 net8.t25 GNDA.t67 GNDA.t66 sky130_fd_pr__nfet_01v8 ad=0.145 pd=1.58 as=0.0725 ps=0.79 w=0.5 l=2
X170 net2.t6 VINN.t0 net7.t30 VDD.t64 sky130_fd_pr__pfet_01v8_lvt ad=1.16 pd=8.58 as=0.58 ps=4.29 w=4 l=2
X171 net7.t46 VINP.t12 net1.t12 VDD.t59 sky130_fd_pr__pfet_01v8_lvt ad=0.58 pd=4.29 as=0.58 ps=4.29 w=4 l=2
X172 net7.t12 VINN.t18 net2.t12 VDD.t67 sky130_fd_pr__pfet_01v8_lvt ad=0.58 pd=4.29 as=0.58 ps=4.29 w=4 l=2
X173 VDD.t5 net5.t19 net3.t0 VDD.t4 sky130_fd_pr__pfet_01v8 ad=0.29 pd=2.29 as=0.29 ps=2.29 w=2 l=2
X174 net3.t19 VINP.t30 net6.t21 GNDA.t59 sky130_fd_pr__nfet_01v8_lvt ad=0.3625 pd=2.79 as=0.3625 ps=2.79 w=2.5 l=2
X175 net12.t5 MN_TAIL_BIAS.t15 VBP_TOP.t13 GNDA.t47 sky130_fd_pr__nfet_01v8 ad=2.9 pd=20.58 as=1.45 ps=10.29 w=10 l=4
X176 net7.t0 net9.t9 VDD.t7 VDD.t6 sky130_fd_pr__pfet_01v8 ad=0.58 pd=4.58 as=0.29 ps=2.29 w=2 l=2
X177 net2.t19 VINN.t25 net7.t5 VDD.t60 sky130_fd_pr__pfet_01v8_lvt ad=0.58 pd=4.29 as=0.58 ps=4.29 w=4 l=2
X178 net4.t1 VBP_CASC.t16 VOUT.t5 VDD.t85 sky130_fd_pr__pfet_01v8 ad=0.0725 pd=0.79 as=0.0725 ps=0.79 w=0.5 l=0.5
X179 net7.t17 VINN.t13 net2.t28 VDD.t65 sky130_fd_pr__pfet_01v8_lvt ad=0.58 pd=4.29 as=1.16 ps=8.58 w=4 l=2
X180 GNDA.t43 net8.t7 net6.t4 GNDA.t21 sky130_fd_pr__nfet_01v8 ad=0.0725 pd=0.79 as=0.145 ps=1.58 w=0.5 l=2
X181 a_8458_6199.t1 net12.t16 GNDA.t108 sky130_fd_pr__res_xhigh_po_1p41 l=6.4
X182 a_9214_6199.t1 a_9592_4519.t1 GNDA.t93 sky130_fd_pr__res_xhigh_po_1p41 l=6.4
X183 net5.t4 VBP_CASC.t9 net3.t6 VDD.t1 sky130_fd_pr__pfet_01v8 ad=0.0725 pd=0.79 as=0.145 ps=1.58 w=0.5 l=0.5
X184 VSTRP_IP.t4 VBP_TOP.t24 VDD.t73 VDD.t72 sky130_fd_pr__pfet_01v8 ad=0.29 pd=2.29 as=0.29 ps=2.29 w=2 l=2
X185 net6.t5 VINN.t35 net4.t12 GNDA.t58 sky130_fd_pr__nfet_01v8_lvt ad=0.3625 pd=2.79 as=0.725 ps=5.58 w=2.5 l=2
X186 a_15596_6577.t1 VDD.t125 a_15442_4519.t0 GNDA.t70 sky130_fd_pr__nfet_01v8 ad=0.145 pd=1.58 as=0.145 ps=1.58 w=0.5 l=10
X187 net7.t59 net9.t6 VDD.t98 VDD.t97 sky130_fd_pr__pfet_01v8 ad=0.29 pd=2.29 as=0.29 ps=2.29 w=2 l=2
X188 net2.t10 VINN.t2 net7.t28 VDD.t62 sky130_fd_pr__pfet_01v8_lvt ad=0.58 pd=4.29 as=0.58 ps=4.29 w=4 l=2
X189 net3.t12 net5.t16 VDD.t57 VDD.t56 sky130_fd_pr__pfet_01v8 ad=0.29 pd=2.29 as=0.29 ps=2.29 w=2 l=2
X190 VSTRP_OUT.t1 net14.t2 a_16520_7509.t0 GNDA.t41 sky130_fd_pr__nfet_01v8 ad=0.29 pd=2.58 as=0.5 ps=3 w=1 l=0.15
X191 net2.t24 VINN.t12 net7.t18 VDD.t66 sky130_fd_pr__pfet_01v8_lvt ad=0.58 pd=4.29 as=0.58 ps=4.29 w=4 l=2
X192 a_14128_6329.t0 a_14506_4519.t1 GNDA.t40 sky130_fd_pr__res_xhigh_po_1p41 l=7.05
X193 net7.t35 VINP.t23 net1.t14 VDD.t69 sky130_fd_pr__pfet_01v8_lvt ad=0.58 pd=4.29 as=0.58 ps=4.29 w=4 l=2
X194 net5.t6 VBP_CASC.t7 net3.t7 VDD.t86 sky130_fd_pr__pfet_01v8 ad=0.0725 pd=0.79 as=0.0725 ps=0.79 w=0.5 l=0.5
X195 net7.t23 VINN.t7 net2.t17 VDD.t71 sky130_fd_pr__pfet_01v8_lvt ad=0.58 pd=4.29 as=0.58 ps=4.29 w=4 l=2
X196 net7.t25 VINN.t5 net2.t23 VDD.t59 sky130_fd_pr__pfet_01v8_lvt ad=0.58 pd=4.29 as=0.58 ps=4.29 w=4 l=2
X197 net9.t2 net8.t16 GNDA.t102 GNDA.t101 sky130_fd_pr__nfet_01v8 ad=0.145 pd=1.58 as=0.0725 ps=0.79 w=0.5 l=2
X198 a_12616_6329.t1 a_12994_4519.t0 GNDA.t17 sky130_fd_pr__res_xhigh_po_1p41 l=7.05
X199 a_16212_6577.t0 VDD.t121 a_16058_4519.t1 GNDA.t74 sky130_fd_pr__nfet_01v8 ad=0.145 pd=1.58 as=0.145 ps=1.58 w=0.5 l=10
X200 VDD.t15 VBP_TOP.t28 net8.t3 VDD.t14 sky130_fd_pr__pfet_01v8 ad=0.29 pd=2.29 as=0.58 ps=4.58 w=2 l=2
X201 net4.t13 VINN.t34 net6.t9 GNDA.t59 sky130_fd_pr__nfet_01v8_lvt ad=0.3625 pd=2.79 as=0.3625 ps=2.79 w=2.5 l=2
X202 VDD.t45 net5.t13 net4.t11 VDD.t44 sky130_fd_pr__pfet_01v8 ad=0.29 pd=2.29 as=0.29 ps=2.29 w=2 l=2
X203 VDD.t13 VBP_TOP.t23 VSTRP_IP.t0 VDD.t12 sky130_fd_pr__pfet_01v8 ad=0.29 pd=2.29 as=0.29 ps=2.29 w=2 l=2
X204 a_16520_7509.t1 EN.t0 GNDA.t85 GNDA.t84 sky130_fd_pr__nfet_01v8 ad=0.29 pd=2.58 as=0.5 ps=3 w=1 l=0.15
X205 net7.t48 VINP.t10 net1.t19 VDD.t61 sky130_fd_pr__pfet_01v8_lvt ad=0.58 pd=4.29 as=0.58 ps=4.29 w=4 l=2
X206 net1.t33 VINP.t22 net7.t36 VDD.t70 sky130_fd_pr__pfet_01v8_lvt ad=0.58 pd=4.29 as=0.58 ps=4.29 w=4 l=2
X207 net2.t9 VINN.t17 net7.t13 VDD.t68 sky130_fd_pr__pfet_01v8_lvt ad=0.58 pd=4.29 as=0.58 ps=4.29 w=4 l=2
X208 net7.t52 VINP.t6 net1.t30 VDD.t65 sky130_fd_pr__pfet_01v8_lvt ad=0.58 pd=4.29 as=1.16 ps=8.58 w=4 l=2
X209 GNDA.t97 net8.t9 net2.t34 GNDA.t2 sky130_fd_pr__nfet_01v8 ad=0.0725 pd=0.79 as=0.0725 ps=0.79 w=0.5 l=2
X210 a_4949_1601.t1 VBN_CASC.t10 GNDA.t81 GNDA.t80 sky130_fd_pr__nfet_01v8 ad=0.0525 pd=0.71 as=0.145 ps=1.58 w=0.5 l=0.5
X211 net1.t35 VBN_CASC.t12 net5.t10 GNDA.t92 sky130_fd_pr__nfet_01v8 ad=0.145 pd=1.58 as=0.0725 ps=0.79 w=0.5 l=0.5
X212 a_5739_8265.t1 VBP_CASC.t5 VDD.t48 VDD.t47 sky130_fd_pr__pfet_01v8 ad=0.0525 pd=0.71 as=0.145 ps=1.58 w=0.5 l=0.5
X213 VOUT.t9 VBN_CASC.t14 net2.t33 GNDA.t90 sky130_fd_pr__nfet_01v8 ad=0.145 pd=1.58 as=0.0725 ps=0.79 w=0.5 l=0.5
X214 net3.t10 net5.t20 VDD.t53 VDD.t52 sky130_fd_pr__pfet_01v8 ad=0.29 pd=2.29 as=0.29 ps=2.29 w=2 l=2
X215 net7.t33 VINP.t25 net1.t18 VDD.t67 sky130_fd_pr__pfet_01v8_lvt ad=0.58 pd=4.29 as=0.58 ps=4.29 w=4 l=2
X216 a_9970_6199.t1 a_9592_4519.t0 GNDA.t29 sky130_fd_pr__res_xhigh_po_1p41 l=6.4
X217 a_8458_6199.t0 a_8836_4519.t1 GNDA.t39 sky130_fd_pr__res_xhigh_po_1p41 l=6.4
X218 net1.t22 VINP.t5 net7.t53 VDD.t66 sky130_fd_pr__pfet_01v8_lvt ad=0.58 pd=4.29 as=0.58 ps=4.29 w=4 l=2
X219 net1.t11 VINP.t20 net7.t38 VDD.t58 sky130_fd_pr__pfet_01v8_lvt ad=0.58 pd=4.29 as=0.58 ps=4.29 w=4 l=2
X220 MN_TAIL_BIAS.t9 VSTRP_OUT.t3 net15.t1 VDD.t96 sky130_fd_pr__pfet_01v8 ad=0.145 pd=1.58 as=0.145 ps=1.58 w=0.5 l=4
X221 GNDA.t110 a_11104_4519.t1 GNDA.t109 sky130_fd_pr__res_xhigh_po_1p41 l=6.4
X222 a_9970_6199.t0 a_10348_4519.t0 GNDA.t16 sky130_fd_pr__res_xhigh_po_1p41 l=6.4
X223 net7.t58 VINP.t0 net1.t20 VDD.t71 sky130_fd_pr__pfet_01v8_lvt ad=0.58 pd=4.29 as=0.58 ps=4.29 w=4 l=2
X224 net7.t43 VINP.t15 net1.t10 VDD.t63 sky130_fd_pr__pfet_01v8_lvt ad=0.58 pd=4.29 as=0.58 ps=4.29 w=4 l=2
R0 VINP.n45 VINP.n26 846.23
R1 VINP.n56 VINP.n45 846.23
R2 VINP.n20 VINP.n19 358.923
R3 VINP.n21 VINP.n16 358.923
R4 VINP.n26 VINP.n25 358.923
R5 VINP.n50 VINP.n49 358.923
R6 VINP.n54 VINP.n47 358.923
R7 VINP.n56 VINP.n55 358.923
R8 VINP.n45 VINP.n44 278.224
R9 VINP.n37 VINP.n35 266.474
R10 VINP.n42 VINP.n28 266.474
R11 VINP.n21 VINP.n20 119.641
R12 VINP.n25 VINP.n16 119.641
R13 VINP.n50 VINP.n47 119.641
R14 VINP.n55 VINP.n54 119.641
R15 VINP.n48 VINP.t0 95.3574
R16 VINP.n18 VINP.t21 95.3574
R17 VINP.n35 VINP.n33 88.8247
R18 VINP.n37 VINP.n28 88.8247
R19 VINP.n44 VINP.n42 88.8247
R20 VINP.n56 VINP.t6 86.3125
R21 VINP.n55 VINP.t5 86.3125
R22 VINP.n54 VINP.t4 86.3125
R23 VINP.n47 VINP.t3 86.3125
R24 VINP.n50 VINP.t2 86.3125
R25 VINP.n49 VINP.t1 86.3125
R26 VINP.n26 VINP.t27 86.3125
R27 VINP.n25 VINP.t26 86.3125
R28 VINP.n16 VINP.t25 86.3125
R29 VINP.n21 VINP.t24 86.3125
R30 VINP.n20 VINP.t23 86.3125
R31 VINP.n19 VINP.t22 86.3125
R32 VINP.n3 VINP.t28 75.3636
R33 VINP.n5 VINP.n4 69.791
R34 VINP.n6 VINP.n5 69.791
R35 VINP.n6 VINP.n1 69.791
R36 VINP.n10 VINP.n1 69.791
R37 VINP.n11 VINP.n10 69.791
R38 VINP.n12 VINP.n11 69.791
R39 VINP.n11 VINP.t35 67.153
R40 VINP.n12 VINP.t31 67.153
R41 VINP.n10 VINP.t34 67.153
R42 VINP.n5 VINP.t33 67.153
R43 VINP.n1 VINP.t30 67.153
R44 VINP.n6 VINP.t29 67.153
R45 VINP.n4 VINP.t32 67.153
R46 VINP.n43 VINP.t20 57.8405
R47 VINP.n43 VINP.t13 57.8405
R48 VINP.n41 VINP.t19 57.8405
R49 VINP.n41 VINP.t12 57.8405
R50 VINP.n27 VINP.t18 57.8405
R51 VINP.n27 VINP.t11 57.8405
R52 VINP.n36 VINP.t17 57.8405
R53 VINP.n36 VINP.t10 57.8405
R54 VINP.n34 VINP.t16 57.8405
R55 VINP.n34 VINP.t9 57.8405
R56 VINP.n32 VINP.t15 57.8405
R57 VINP.n32 VINP.t8 57.8405
R58 VINP.n30 VINP.t14 57.8405
R59 VINP.n30 VINP.t7 57.8405
R60 VINP.n31 VINP.n30 42.4268
R61 VINP.n33 VINP.n32 30.4005
R62 VINP.n35 VINP.n34 30.4005
R63 VINP.n37 VINP.n36 30.4005
R64 VINP.n28 VINP.n27 30.4005
R65 VINP.n42 VINP.n41 30.4005
R66 VINP.n44 VINP.n43 30.4005
R67 VINP VINP.n13 14.3631
R68 VINP.n5 VINP.n2 9.3005
R69 VINP.n7 VINP.n6 9.3005
R70 VINP.n8 VINP.n1 9.3005
R71 VINP.n10 VINP.n9 9.3005
R72 VINP.n11 VINP.n0 9.3005
R73 VINP.n20 VINP.n17 9.3005
R74 VINP.n22 VINP.n21 9.3005
R75 VINP.n23 VINP.n16 9.3005
R76 VINP.n25 VINP.n24 9.3005
R77 VINP.n26 VINP.n15 9.3005
R78 VINP.n35 VINP.n29 9.3005
R79 VINP.n38 VINP.n37 9.3005
R80 VINP.n39 VINP.n28 9.3005
R81 VINP.n42 VINP.n40 9.3005
R82 VINP.n44 VINP.n14 9.3005
R83 VINP.n51 VINP.n50 9.3005
R84 VINP.n52 VINP.n47 9.3005
R85 VINP.n54 VINP.n53 9.3005
R86 VINP.n55 VINP.n46 9.3005
R87 VINP.n57 VINP.n56 9.3005
R88 VINP.n58 VINP.n45 9.3005
R89 VINP VINP.n58 9.05125
R90 VINP.n33 VINP.n31 8.58182
R91 VINP.n13 VINP.n12 8.48723
R92 VINP.n19 VINP.n18 7.97789
R93 VINP.n49 VINP.n48 7.97789
R94 VINP.n4 VINP.n3 7.24205
R95 VINP.n58 VINP.n15 4.95449
R96 VINP.n58 VINP.n57 4.95449
R97 VINP.n18 VINP.n17 4.43774
R98 VINP.n51 VINP.n48 4.43774
R99 VINP.n23 VINP.n22 3.7342
R100 VINP.n24 VINP.n15 3.7342
R101 VINP.n38 VINP.n29 3.7342
R102 VINP.n40 VINP.n39 3.7342
R103 VINP.n53 VINP.n52 3.7342
R104 VINP.n57 VINP.n46 3.7342
R105 VINP.n3 VINP.n2 2.33961
R106 VINP.n58 VINP.n14 2.19009
R107 VINP.n31 VINP.n29 1.66527
R108 VINP.n13 VINP.n0 1.32028
R109 VINP.n7 VINP.n2 1.24507
R110 VINP.n8 VINP.n7 1.24507
R111 VINP.n9 VINP.n8 1.24507
R112 VINP.n9 VINP.n0 1.24507
R113 VINP.n22 VINP.n17 1.24507
R114 VINP.n24 VINP.n23 1.24507
R115 VINP.n39 VINP.n38 1.24507
R116 VINP.n40 VINP.n14 1.24507
R117 VINP.n52 VINP.n51 1.24507
R118 VINP.n53 VINP.n46 1.24507
R119 VINN.n65 VINN.n60 544.74
R120 VINN.n51 VINN.n26 459.209
R121 VINN.n26 VINN.n25 458.834
R122 VINN.n60 VINN.n59 372.317
R123 VINN.n64 VINN.n63 303.228
R124 VINN.n59 VINN.n58 303.228
R125 VINN.n65 VINN.n64 101.076
R126 VINN.n58 VINN.n55 101.076
R127 VINN.n38 VINN.t13 94.7104
R128 VINN.n6 VINN.t20 94.7104
R129 VINN.n7 VINN.t27 86.3125
R130 VINN.n8 VINN.t26 86.3125
R131 VINN.n13 VINN.t25 86.3125
R132 VINN.n5 VINN.t19 86.3125
R133 VINN.n12 VINN.t18 86.3125
R134 VINN.n14 VINN.t24 86.3125
R135 VINN.n19 VINN.t23 86.3125
R136 VINN.n3 VINN.t17 86.3125
R137 VINN.n18 VINN.t16 86.3125
R138 VINN.n20 VINN.t22 86.3125
R139 VINN.n25 VINN.t21 86.3125
R140 VINN.n1 VINN.t15 86.3125
R141 VINN.n24 VINN.t14 86.3125
R142 VINN.n41 VINN.t12 86.3125
R143 VINN.n39 VINN.t6 86.3125
R144 VINN.n40 VINN.t5 86.3125
R145 VINN.n42 VINN.t11 86.3125
R146 VINN.n45 VINN.t10 86.3125
R147 VINN.n43 VINN.t4 86.3125
R148 VINN.n44 VINN.t3 86.3125
R149 VINN.n46 VINN.t9 86.3125
R150 VINN.n49 VINN.t8 86.3125
R151 VINN.n47 VINN.t2 86.3125
R152 VINN.n48 VINN.t1 86.3125
R153 VINN.n50 VINN.t7 86.3125
R154 VINN.n51 VINN.t0 86.3125
R155 VINN.n51 VINN.n50 82.5695
R156 VINN.n50 VINN.n49 82.5695
R157 VINN.n49 VINN.n48 82.5695
R158 VINN.n48 VINN.n47 82.5695
R159 VINN.n47 VINN.n46 82.5695
R160 VINN.n46 VINN.n45 82.5695
R161 VINN.n45 VINN.n44 82.5695
R162 VINN.n44 VINN.n43 82.5695
R163 VINN.n43 VINN.n42 82.5695
R164 VINN.n42 VINN.n41 82.5695
R165 VINN.n41 VINN.n40 82.5695
R166 VINN.n40 VINN.n39 82.5695
R167 VINN.n25 VINN.n24 82.5695
R168 VINN.n24 VINN.n1 82.5695
R169 VINN.n20 VINN.n1 82.5695
R170 VINN.n20 VINN.n19 82.5695
R171 VINN.n19 VINN.n18 82.5695
R172 VINN.n18 VINN.n3 82.5695
R173 VINN.n14 VINN.n3 82.5695
R174 VINN.n14 VINN.n13 82.5695
R175 VINN.n13 VINN.n12 82.5695
R176 VINN.n12 VINN.n5 82.5695
R177 VINN.n8 VINN.n5 82.5695
R178 VINN.n8 VINN.n7 82.5695
R179 VINN.n56 VINN.t35 79.2931
R180 VINN.n62 VINN.t31 75.9676
R181 VINN.n55 VINN.t34 67.153
R182 VINN.n58 VINN.t33 67.153
R183 VINN.n59 VINN.t32 67.153
R184 VINN.n63 VINN.t30 67.153
R185 VINN.n64 VINN.t29 67.153
R186 VINN.n65 VINN.t28 67.153
R187 VINN.n68 VINN.n67 11.4084
R188 VINN.n68 VINN.n53 10.2309
R189 VINN.n66 VINN.n65 9.3005
R190 VINN.n64 VINN.n61 9.3005
R191 VINN.n59 VINN.n54 9.3005
R192 VINN.n58 VINN.n57 9.3005
R193 VINN.n67 VINN.n60 9.3005
R194 VINN.n50 VINN.n27 9.3005
R195 VINN.n49 VINN.n28 9.3005
R196 VINN.n46 VINN.n31 9.3005
R197 VINN.n45 VINN.n32 9.3005
R198 VINN.n42 VINN.n35 9.3005
R199 VINN.n41 VINN.n36 9.3005
R200 VINN.n40 VINN.n37 9.3005
R201 VINN.n43 VINN.n34 9.3005
R202 VINN.n44 VINN.n33 9.3005
R203 VINN.n47 VINN.n30 9.3005
R204 VINN.n48 VINN.n29 9.3005
R205 VINN.n52 VINN.n51 9.3005
R206 VINN.n25 VINN.n0 9.3005
R207 VINN.n24 VINN.n23 9.3005
R208 VINN.n22 VINN.n1 9.3005
R209 VINN.n21 VINN.n20 9.3005
R210 VINN.n19 VINN.n2 9.3005
R211 VINN.n18 VINN.n17 9.3005
R212 VINN.n16 VINN.n3 9.3005
R213 VINN.n15 VINN.n14 9.3005
R214 VINN.n13 VINN.n4 9.3005
R215 VINN.n12 VINN.n11 9.3005
R216 VINN.n10 VINN.n5 9.3005
R217 VINN.n9 VINN.n8 9.3005
R218 VINN.n53 VINN.n26 9.3005
R219 VINN.n56 VINN.n55 8.66301
R220 VINN.n63 VINN.n62 7.77475
R221 VINN.n39 VINN.n38 7.50948
R222 VINN.n7 VINN.n6 7.50948
R223 VINN.n62 VINN.n61 4.54568
R224 VINN.n57 VINN.n54 3.7342
R225 VINN.n67 VINN.n66 3.56363
R226 VINN.n53 VINN.n52 2.84329
R227 VINN.n53 VINN.n0 2.84121
R228 VINN.n67 VINN.n54 2.31907
R229 VINN.n38 VINN.n37 2.04778
R230 VINN.n9 VINN.n6 2.04778
R231 VINN.n57 VINN.n56 1.61789
R232 VINN VINN.n68 1.4058
R233 VINN.n66 VINN.n61 1.24507
R234 VINN.n52 VINN.n27 1.10146
R235 VINN.n28 VINN.n27 1.10146
R236 VINN.n29 VINN.n28 1.10146
R237 VINN.n30 VINN.n29 1.10146
R238 VINN.n31 VINN.n30 1.10146
R239 VINN.n32 VINN.n31 1.10146
R240 VINN.n33 VINN.n32 1.10146
R241 VINN.n34 VINN.n33 1.10146
R242 VINN.n35 VINN.n34 1.10146
R243 VINN.n36 VINN.n35 1.10146
R244 VINN.n37 VINN.n36 1.10146
R245 VINN.n23 VINN.n0 1.10146
R246 VINN.n23 VINN.n22 1.10146
R247 VINN.n22 VINN.n21 1.10146
R248 VINN.n21 VINN.n2 1.10146
R249 VINN.n17 VINN.n2 1.10146
R250 VINN.n17 VINN.n16 1.10146
R251 VINN.n16 VINN.n15 1.10146
R252 VINN.n15 VINN.n4 1.10146
R253 VINN.n11 VINN.n4 1.10146
R254 VINN.n11 VINN.n10 1.10146
R255 VINN.n10 VINN.n9 1.10146
R256 MN_TAIL_BIAS.n0 MN_TAIL_BIAS.t9 660.59
R257 MN_TAIL_BIAS.n23 MN_TAIL_BIAS.n4 390.776
R258 MN_TAIL_BIAS.n25 MN_TAIL_BIAS.n23 390.776
R259 MN_TAIL_BIAS.n13 MN_TAIL_BIAS.n11 365.176
R260 MN_TAIL_BIAS.n22 MN_TAIL_BIAS.n20 365.176
R261 MN_TAIL_BIAS.n7 MN_TAIL_BIAS.n5 336.83
R262 MN_TAIL_BIAS.n16 MN_TAIL_BIAS.n14 336.83
R263 MN_TAIL_BIAS.n9 MN_TAIL_BIAS.n7 323.012
R264 MN_TAIL_BIAS.n11 MN_TAIL_BIAS.n9 323.012
R265 MN_TAIL_BIAS.n20 MN_TAIL_BIAS.n18 323.012
R266 MN_TAIL_BIAS.n18 MN_TAIL_BIAS.n16 323.012
R267 MN_TAIL_BIAS.n0 MN_TAIL_BIAS.t10 234.938
R268 MN_TAIL_BIAS.n23 MN_TAIL_BIAS.n13 161.506
R269 MN_TAIL_BIAS.n23 MN_TAIL_BIAS.n22 161.506
R270 MN_TAIL_BIAS.n1 MN_TAIL_BIAS.t8 119.347
R271 MN_TAIL_BIAS.n14 MN_TAIL_BIAS.t26 63.5643
R272 MN_TAIL_BIAS.n14 MN_TAIL_BIAS.t18 63.5643
R273 MN_TAIL_BIAS.n15 MN_TAIL_BIAS.t25 63.5643
R274 MN_TAIL_BIAS.n15 MN_TAIL_BIAS.t17 63.5643
R275 MN_TAIL_BIAS.n17 MN_TAIL_BIAS.t24 63.5643
R276 MN_TAIL_BIAS.n17 MN_TAIL_BIAS.t16 63.5643
R277 MN_TAIL_BIAS.n19 MN_TAIL_BIAS.t23 63.5643
R278 MN_TAIL_BIAS.n19 MN_TAIL_BIAS.t15 63.5643
R279 MN_TAIL_BIAS.n21 MN_TAIL_BIAS.t4 63.5643
R280 MN_TAIL_BIAS.n21 MN_TAIL_BIAS.t2 63.5643
R281 MN_TAIL_BIAS.n12 MN_TAIL_BIAS.t6 63.5643
R282 MN_TAIL_BIAS.n12 MN_TAIL_BIAS.t0 63.5643
R283 MN_TAIL_BIAS.n10 MN_TAIL_BIAS.t22 63.5643
R284 MN_TAIL_BIAS.n10 MN_TAIL_BIAS.t14 63.5643
R285 MN_TAIL_BIAS.n8 MN_TAIL_BIAS.t21 63.5643
R286 MN_TAIL_BIAS.n8 MN_TAIL_BIAS.t13 63.5643
R287 MN_TAIL_BIAS.n6 MN_TAIL_BIAS.t20 63.5643
R288 MN_TAIL_BIAS.n6 MN_TAIL_BIAS.t12 63.5643
R289 MN_TAIL_BIAS.n5 MN_TAIL_BIAS.t19 63.5643
R290 MN_TAIL_BIAS.n5 MN_TAIL_BIAS.t11 63.5643
R291 MN_TAIL_BIAS.n7 MN_TAIL_BIAS.n6 13.8187
R292 MN_TAIL_BIAS.n9 MN_TAIL_BIAS.n8 13.8187
R293 MN_TAIL_BIAS.n11 MN_TAIL_BIAS.n10 13.8187
R294 MN_TAIL_BIAS.n13 MN_TAIL_BIAS.n12 13.8187
R295 MN_TAIL_BIAS.n22 MN_TAIL_BIAS.n21 13.8187
R296 MN_TAIL_BIAS.n20 MN_TAIL_BIAS.n19 13.8187
R297 MN_TAIL_BIAS.n18 MN_TAIL_BIAS.n17 13.8187
R298 MN_TAIL_BIAS.n16 MN_TAIL_BIAS.n15 13.8187
R299 MN_TAIL_BIAS.n4 MN_TAIL_BIAS.n2 12.1423
R300 MN_TAIL_BIAS.n26 MN_TAIL_BIAS.n25 12.1423
R301 MN_TAIL_BIAS.n4 MN_TAIL_BIAS.n3 6.37981
R302 MN_TAIL_BIAS.n25 MN_TAIL_BIAS.n24 6.37981
R303 MN_TAIL_BIAS.n2 MN_TAIL_BIAS.n1 6.019
R304 MN_TAIL_BIAS.n1 MN_TAIL_BIAS.n0 3.938
R305 MN_TAIL_BIAS.n24 MN_TAIL_BIAS.t1 1.7405
R306 MN_TAIL_BIAS.n24 MN_TAIL_BIAS.t3 1.7405
R307 MN_TAIL_BIAS.n3 MN_TAIL_BIAS.t7 1.7405
R308 MN_TAIL_BIAS.n3 MN_TAIL_BIAS.t5 1.7405
R309 MN_TAIL_BIAS.n26 MN_TAIL_BIAS.n2 1.24012
R310 MN_TAIL_BIAS MN_TAIL_BIAS.n26 0.943437
R311 VOUT.n2 VOUT.n0 599.987
R312 VOUT.n2 VOUT.n1 599.33
R313 VOUT.n4 VOUT.n3 599.33
R314 VOUT.n6 VOUT.n5 599.33
R315 VOUT.n7 VOUT.t0 235.008
R316 VOUT.n7 VOUT.t9 234.351
R317 VOUT.n8 VOUT.t6 234.351
R318 VOUT.n0 VOUT.t5 57.1305
R319 VOUT.n0 VOUT.t2 57.1305
R320 VOUT.n1 VOUT.t1 57.1305
R321 VOUT.n1 VOUT.t3 57.1305
R322 VOUT.n3 VOUT.t7 57.1305
R323 VOUT.n3 VOUT.t4 57.1305
R324 VOUT.n5 VOUT.t8 57.1305
R325 VOUT.n5 VOUT.t10 57.1305
R326 VOUT.n9 VOUT.n6 14.2005
R327 VOUT.n9 VOUT.n8 10.3647
R328 VOUT.n8 VOUT.n7 1.45467
R329 VOUT VOUT.n9 1.11851
R330 VOUT.n4 VOUT.n2 0.892167
R331 VOUT.n6 VOUT.n4 0.658833
R332 EN.n5 EN.t0 496.478
R333 EN.n3 EN.t2 458.829
R334 EN.n3 EN.t1 446.209
R335 EN.n1 EN.t3 118.102
R336 EN.n0 EN.t5 80.7828
R337 EN.n2 EN.t6 76.1519
R338 EN.n0 EN.t4 76.1183
R339 EN.n2 EN.n1 7.13383
R340 EN.n4 EN.n2 5.99217
R341 EN.n4 EN.n3 5.09425
R342 EN.n1 EN.n0 3.14633
R343 EN.n5 EN.n4 1.66717
R344 EN EN.n5 0.271333
R345 VDD.n6 VDD.n3 11292.4
R346 VDD.n8 VDD.n3 11292.4
R347 VDD.n8 VDD.n5 11292.4
R348 VDD.n6 VDD.n5 11292.4
R349 VDD.n4 VDD.n2 2059.29
R350 VDD.n10 VDD.n2 2059.29
R351 VDD.n9 VDD.n4 2059.29
R352 VDD.n10 VDD.n9 2059.29
R353 VDD.t54 VDD.t39 1208.31
R354 VDD.n56 VDD.t78 652.538
R355 VDD.n11 VDD.t48 652.468
R356 VDD.n42 VDD.n40 472.471
R357 VDD.t110 VDD.t96 442.498
R358 VDD.t96 VDD.t103 440.786
R359 VDD.n49 VDD.n22 389.272
R360 VDD.n43 VDD.n42 344.848
R361 VDD.n49 VDD.n48 344.848
R362 VDD.n57 VDD.n22 313.976
R363 VDD.n43 VDD.n27 312.471
R364 VDD.t113 VDD.t93 307.923
R365 VDD.t16 VDD.t110 261.164
R366 VDD.t24 VDD.t37 261.164
R367 VDD.t42 VDD.t18 261.164
R368 VDD.t18 VDD.t10 261.164
R369 VDD.t50 VDD.t77 250.9
R370 VDD.n32 VDD.t116 250.129
R371 VDD.n39 VDD.t104 250.129
R372 VDD.n36 VDD.t76 250.129
R373 VDD.n34 VDD.t35 250.129
R374 VDD.t99 VDD.t72 240.637
R375 VDD.t97 VDD.t87 240.637
R376 VDD.t8 VDD.t28 240.637
R377 VDD.n61 VDD.n60 226.148
R378 VDD.n23 VDD.t126 225.744
R379 VDD.n60 VDD.n57 216.847
R380 VDD.t81 VDD.t16 214.406
R381 VDD.t34 VDD.t115 193.879
R382 VDD.t75 VDD.t34 193.879
R383 VDD.t103 VDD.t75 193.879
R384 VDD.t6 VDD.t2 193.879
R385 VDD.t101 VDD.t14 193.879
R386 VDD.t44 VDD.t79 192.738
R387 VDD.t39 VDD.n78 183.043
R388 VDD.n26 VDD.t12 179.623
R389 VDD.t41 VDD.t22 153.963
R390 VDD.t32 VDD.t20 142.558
R391 VDD.t30 VDD.t42 142.558
R392 VDD.n33 VDD.n32 137.3
R393 VDD.n33 VDD.n31 128
R394 VDD.n40 VDD.n31 128
R395 VDD.t64 VDD.n5 117.309
R396 VDD.t65 VDD.n3 117.309
R397 VDD.n16 VDD.t82 115.51
R398 VDD.n61 VDD.t74 115.112
R399 VDD.n41 VDD.t111 115.112
R400 VDD.n63 VDD.t80 115.043
R401 VDD.t56 VDD.t1 109.484
R402 VDD.t4 VDD.t36 109.484
R403 VDD.t71 VDD.t64 104.793
R404 VDD.t70 VDD.t71 104.793
R405 VDD.t63 VDD.t70 104.793
R406 VDD.t62 VDD.t63 104.793
R407 VDD.t69 VDD.t62 104.793
R408 VDD.t68 VDD.t69 104.793
R409 VDD.t61 VDD.t60 104.793
R410 VDD.t60 VDD.t67 104.793
R411 VDD.t67 VDD.t66 104.793
R412 VDD.t66 VDD.t59 104.793
R413 VDD.t59 VDD.t58 104.793
R414 VDD.t58 VDD.t65 104.793
R415 VDD.n59 VDD.n58 100.829
R416 VDD.n53 VDD.n52 100.829
R417 VDD.n50 VDD.n25 100.829
R418 VDD.n47 VDD.n28 100.829
R419 VDD.n44 VDD.n30 100.829
R420 VDD.n1 VDD.n0 99.9855
R421 VDD.n70 VDD.n69 99.9855
R422 VDD.n71 VDD.n68 99.9855
R423 VDD.n72 VDD.n67 99.9855
R424 VDD.n73 VDD.n66 99.9855
R425 VDD.n74 VDD.n65 99.9855
R426 VDD.n76 VDD.n20 99.9855
R427 VDD.n19 VDD.n12 99.9855
R428 VDD.n18 VDD.n13 99.9855
R429 VDD.n17 VDD.n14 99.9855
R430 VDD.n16 VDD.n15 99.9855
R431 VDD.t86 VDD.t32 90.0965
R432 VDD.t1 VDD.t49 90.0965
R433 VDD.t112 VDD.t92 90.0965
R434 VDD.t31 VDD.t85 90.0965
R435 VDD.t85 VDD.t23 90.0965
R436 VDD.t36 VDD.t95 90.0965
R437 VDD.t33 VDD.t30 90.0965
R438 VDD.t46 VDD.t105 80.9729
R439 VDD.t47 VDD.t46 80.9729
R440 VDD.n78 VDD.t108 78.1217
R441 VDD.t77 VDD.t6 77.5515
R442 VDD.t79 VDD.t54 68.4279
R443 VDD.t2 VDD.t101 67.2874
R444 VDD.t14 VDD.t108 67.2874
R445 VDD.t49 VDD.t89 61.5851
R446 VDD.t95 VDD.t52 61.5851
R447 VDD.n26 VDD.t26 61.0149
R448 VDD.t83 VDD.t41 53.6019
R449 VDD.t22 VDD.t106 53.6019
R450 VDD.n7 VDD.t68 52.3969
R451 VDD.n7 VDD.t61 52.3969
R452 VDD.n79 VDD.t112 51.8913
R453 VDD.t105 VDD.t44 50.1806
R454 VDD.t20 VDD.t47 49.0401
R455 VDD.t37 VDD.t81 46.7592
R456 VDD.t92 VDD.t56 44.4783
R457 VDD.t23 VDD.t4 44.4783
R458 VDD.n79 VDD.t91 38.2058
R459 VDD.t91 VDD.t83 36.4951
R460 VDD.t106 VDD.t31 36.4951
R461 VDD.n48 VDD.n27 32.377
R462 VDD.t89 VDD.t86 28.5119
R463 VDD.t52 VDD.t33 28.5119
R464 VDD.t26 VDD.t24 20.5287
R465 VDD.t12 VDD.t99 20.5287
R466 VDD.t72 VDD.t97 20.5287
R467 VDD.t87 VDD.t113 20.5287
R468 VDD.t93 VDD.t8 20.5287
R469 VDD.t28 VDD.t50 20.5287
R470 VDD.n0 VDD.t19 14.283
R471 VDD.n0 VDD.t11 14.283
R472 VDD.n69 VDD.t53 14.283
R473 VDD.n69 VDD.t43 14.283
R474 VDD.n68 VDD.t107 14.283
R475 VDD.n68 VDD.t5 14.283
R476 VDD.n67 VDD.t57 14.283
R477 VDD.n67 VDD.t84 14.283
R478 VDD.n66 VDD.t21 14.283
R479 VDD.n66 VDD.t90 14.283
R480 VDD.n65 VDD.t55 14.283
R481 VDD.n65 VDD.t45 14.283
R482 VDD.n58 VDD.t3 14.283
R483 VDD.n58 VDD.t15 14.283
R484 VDD.n52 VDD.t94 14.283
R485 VDD.n52 VDD.t29 14.283
R486 VDD.n25 VDD.t73 14.283
R487 VDD.n25 VDD.t88 14.283
R488 VDD.n28 VDD.t25 14.283
R489 VDD.n28 VDD.t13 14.283
R490 VDD.n30 VDD.t17 14.283
R491 VDD.n30 VDD.t38 14.283
R492 VDD.n20 VDD.t109 14.283
R493 VDD.n20 VDD.t40 14.283
R494 VDD.n12 VDD.t7 14.283
R495 VDD.n12 VDD.t102 14.283
R496 VDD.n13 VDD.t9 14.283
R497 VDD.n13 VDD.t51 14.283
R498 VDD.n14 VDD.t98 14.283
R499 VDD.n14 VDD.t114 14.283
R500 VDD.n15 VDD.t27 14.283
R501 VDD.n15 VDD.t100 14.283
R502 VDD.n34 VDD.n33 9.3005
R503 VDD.n36 VDD.n31 9.3005
R504 VDD.n40 VDD.n39 9.3005
R505 VDD.n42 VDD.n41 9.3005
R506 VDD.n44 VDD.n43 9.3005
R507 VDD.n48 VDD.n47 9.3005
R508 VDD.n50 VDD.n49 9.3005
R509 VDD.n53 VDD.n22 9.3005
R510 VDD.n57 VDD.n56 9.3005
R511 VDD.n60 VDD.n59 9.3005
R512 VDD.n23 VDD.t0 9.17464
R513 VDD.n81 VDD.n80 8.26774
R514 VDD.n81 VDD.n10 8.20536
R515 VDD.n64 VDD.n62 5.8255
R516 VDD.n35 VDD.n32 5.20883
R517 VDD.n24 VDD.n23 4.74824
R518 VDD.n35 VDD.n34 4.5005
R519 VDD.n37 VDD.n36 4.5005
R520 VDD.n39 VDD.n38 4.5005
R521 VDD.n41 VDD.n29 4.5005
R522 VDD.n45 VDD.n44 4.5005
R523 VDD.n47 VDD.n46 4.5005
R524 VDD.n51 VDD.n50 4.5005
R525 VDD.n54 VDD.n53 4.5005
R526 VDD.n56 VDD.n55 4.5005
R527 VDD.n59 VDD.n21 4.5005
R528 VDD.n62 VDD.n61 4.5005
R529 VDD.n75 VDD.n74 4.18369
R530 VDD.t118 VDD.t117 3.7119
R531 VDD.t119 VDD.t118 3.7119
R532 VDD.t120 VDD.t119 3.7119
R533 VDD.t121 VDD.t120 3.7119
R534 VDD.t122 VDD.t121 3.7119
R535 VDD.t123 VDD.t122 3.7119
R536 VDD.t124 VDD.t123 3.7119
R537 VDD.t125 VDD.t124 3.7119
R538 VDD.n64 VDD.n63 3.45524
R539 VDD VDD.n81 3.34964
R540 VDD.n80 VDD.n79 3.33223
R541 VDD.n75 VDD.n64 3.18584
R542 VDD.n5 VDD.n4 3.13609
R543 VDD.n10 VDD.n3 3.13609
R544 VDD.n27 VDD.n26 2.76169
R545 VDD.n80 VDD.n11 2.69447
R546 VDD.n38 VDD.n29 2.61508
R547 VDD.t126 VDD.t125 2.5069
R548 VDD VDD.n1 2.39274
R549 VDD.n18 VDD.n17 2.22895
R550 VDD.n19 VDD.n18 2.22895
R551 VDD.n63 VDD.n11 2.19447
R552 VDD.n54 VDD.n51 2.15467
R553 VDD.n17 VDD.n16 1.97464
R554 VDD.n74 VDD.n73 1.97464
R555 VDD.n73 VDD.n72 1.97464
R556 VDD.n72 VDD.n71 1.97464
R557 VDD.n71 VDD.n70 1.97464
R558 VDD.n70 VDD.n1 1.97464
R559 VDD.n45 VDD.n29 1.90883
R560 VDD.n46 VDD.n45 1.90883
R561 VDD.n6 VDD.n2 1.83218
R562 VDD.n7 VDD.n6 1.83218
R563 VDD.n9 VDD.n8 1.83218
R564 VDD.n8 VDD.n7 1.83218
R565 VDD.n77 VDD.n19 1.77636
R566 VDD.n55 VDD.n54 1.738
R567 VDD.n46 VDD.n24 1.67342
R568 VDD.n78 VDD.n77 1.52602
R569 VDD.n76 VDD.n75 1.37119
R570 VDD.n55 VDD.n21 1.2005
R571 VDD.n62 VDD.n21 1.2005
R572 VDD.n37 VDD.n35 0.708833
R573 VDD.n38 VDD.n37 0.708833
R574 VDD.n51 VDD.n24 0.235917
R575 VDD.n77 VDD.n76 0.198776
R576 GNDA.t7 GNDA.n71 56096.5
R577 GNDA.n60 GNDA.n19 22624.4
R578 GNDA.n18 GNDA.n17 22624.4
R579 GNDA.n60 GNDA.n18 22624.4
R580 GNDA.n24 GNDA.n17 15420.3
R581 GNDA.n30 GNDA.n24 13389.2
R582 GNDA.n70 GNDA.n11 9544.31
R583 GNDA.n70 GNDA.n12 9544.31
R584 GNDA.n14 GNDA.n12 9544.31
R585 GNDA.n14 GNDA.n11 9544.31
R586 GNDA.n24 GNDA.n19 7204.09
R587 GNDA.n28 GNDA.n27 3913.23
R588 GNDA.n59 GNDA.n20 2512.19
R589 GNDA.n23 GNDA.n20 2512.19
R590 GNDA.n59 GNDA.n58 2512.19
R591 GNDA.n57 GNDA.n23 1709.18
R592 GNDA.n57 GNDA.n56 1484.05
R593 GNDA.t10 GNDA.t27 1458.51
R594 GNDA.n27 GNDA.t61 1356.98
R595 GNDA.n71 GNDA.t58 1356.98
R596 GNDA.t18 GNDA.t66 1267.31
R597 GNDA.t61 GNDA.t65 1245.49
R598 GNDA.t65 GNDA.t64 1245.49
R599 GNDA.t64 GNDA.t60 1245.49
R600 GNDA.t59 GNDA.t63 1245.49
R601 GNDA.t63 GNDA.t62 1245.49
R602 GNDA.t62 GNDA.t58 1245.49
R603 GNDA.n67 GNDA.n13 1062.4
R604 GNDA.n69 GNDA.n13 1062.4
R605 GNDA.n69 GNDA.n68 1062.4
R606 GNDA.n68 GNDA.n67 1062.4
R607 GNDA.t27 GNDA.t101 1018.29
R608 GNDA.t31 GNDA.t18 1018.29
R609 GNDA.t66 GNDA.t7 1018.29
R610 GNDA.n58 GNDA.n57 803.013
R611 GNDA.t60 GNDA.n26 622.745
R612 GNDA.n26 GNDA.t59 622.745
R613 GNDA.t104 GNDA.t10 622.538
R614 GNDA.t14 GNDA.t24 600.303
R615 GNDA.t101 GNDA.n28 564.731
R616 GNDA.t2 GNDA.t80 471.349
R617 GNDA.n28 GNDA.n25 458.796
R618 GNDA.n72 GNDA.t90 389.086
R619 GNDA.n29 GNDA.t89 346.842
R620 GNDA.t107 GNDA.t104 315.716
R621 GNDA.t86 GNDA.t98 315.716
R622 GNDA.t38 GNDA.t86 315.716
R623 GNDA.t30 GNDA.t38 315.716
R624 GNDA.t80 GNDA.t37 315.716
R625 GNDA.t89 GNDA.t2 275.695
R626 GNDA.t24 GNDA.t31 275.695
R627 GNDA.n18 GNDA.t84 267.075
R628 GNDA.n29 GNDA.t92 253.462
R629 GNDA.t98 GNDA.t21 235.675
R630 GNDA.t37 GNDA.t4 231.228
R631 GNDA.n35 GNDA.t79 230.198
R632 GNDA.n48 GNDA.t112 230.138
R633 GNDA.n10 GNDA.t81 229.851
R634 GNDA.n64 GNDA.t114 229.803
R635 GNDA.t26 GNDA.t40 214.635
R636 GNDA.t111 GNDA.t94 214.635
R637 GNDA.t94 GNDA.t25 214.635
R638 GNDA.t6 GNDA.t88 214.635
R639 GNDA.t109 GNDA.t6 214.635
R640 GNDA.t87 GNDA.t20 214.635
R641 GNDA.t29 GNDA.t16 214.635
R642 GNDA.n72 GNDA.t33 211.219
R643 GNDA.t34 GNDA.t33 208.994
R644 GNDA.t90 GNDA.t12 208.994
R645 GNDA.t40 GNDA.t52 203.846
R646 GNDA.n8 GNDA.n7 197.739
R647 GNDA.t69 GNDA.t53 196.464
R648 GNDA.n49 GNDA.n32 195.339
R649 GNDA.n50 GNDA.n31 195.339
R650 GNDA.n54 GNDA.n51 195.339
R651 GNDA.n53 GNDA.n52 195.339
R652 GNDA.n1 GNDA.n0 195.339
R653 GNDA.n76 GNDA.n2 195.339
R654 GNDA.n75 GNDA.n3 195.339
R655 GNDA.n74 GNDA.n4 195.339
R656 GNDA.n9 GNDA.n5 195.339
R657 GNDA.n8 GNDA.n6 195.339
R658 GNDA.t45 GNDA.t29 191.355
R659 GNDA.t108 GNDA.t44 179.998
R660 GNDA.t48 GNDA.t9 168.642
R661 GNDA.t92 GNDA.t34 142.294
R662 GNDA.t12 GNDA.t14 142.294
R663 GNDA.n25 GNDA.t108 141.954
R664 GNDA.t17 GNDA.n61 139.684
R665 GNDA.t20 GNDA.t47 139.115
R666 GNDA.t46 GNDA.t87 133.438
R667 GNDA.t95 GNDA.t93 123.216
R668 GNDA.t0 GNDA.t15 111.861
R669 GNDA.t25 GNDA.t50 110.725
R670 GNDA.t39 GNDA.t0 102.775
R671 GNDA.n34 GNDA.t83 96.8989
R672 GNDA.n16 GNDA.t100 96.8989
R673 GNDA.n36 GNDA.t85 96.8989
R674 GNDA.t15 GNDA.t95 91.4188
R675 GNDA.t76 GNDA.t75 87.444
R676 GNDA.t74 GNDA.t73 87.444
R677 GNDA.t72 GNDA.t71 87.444
R678 GNDA.t71 GNDA.t70 87.444
R679 GNDA.t70 GNDA.t69 87.444
R680 GNDA.t4 GNDA.t30 84.4876
R681 GNDA.t16 GNDA.t46 81.1981
R682 GNDA.t21 GNDA.t107 80.0409
R683 GNDA.n62 GNDA.t50 78.9268
R684 GNDA.t55 GNDA.t77 78.359
R685 GNDA.t47 GNDA.t109 75.5199
R686 GNDA.t75 GNDA.t82 68.7061
R687 GNDA.t53 GNDA.t26 68.7061
R688 GNDA.n66 GNDA.n15 66.8989
R689 GNDA.t73 GNDA.t54 59.0533
R690 GNDA.t84 GNDA.t78 55.0786
R691 GNDA.t77 GNDA.t41 50.5361
R692 GNDA.t88 GNDA.t48 45.9935
R693 GNDA.n61 GNDA.t113 38.6119
R694 GNDA.t41 GNDA.t76 36.9085
R695 GNDA.t9 GNDA.t113 36.3407
R696 GNDA.n32 GNDA.t36 34.8005
R697 GNDA.n32 GNDA.t43 34.8005
R698 GNDA.n31 GNDA.t5 34.8005
R699 GNDA.n31 GNDA.t97 34.8005
R700 GNDA.n51 GNDA.t105 34.8005
R701 GNDA.n51 GNDA.t23 34.8005
R702 GNDA.n52 GNDA.t106 34.8005
R703 GNDA.n52 GNDA.t103 34.8005
R704 GNDA.n0 GNDA.t68 34.8005
R705 GNDA.n0 GNDA.t8 34.8005
R706 GNDA.n2 GNDA.t67 34.8005
R707 GNDA.n2 GNDA.t91 34.8005
R708 GNDA.n3 GNDA.t32 34.8005
R709 GNDA.n3 GNDA.t19 34.8005
R710 GNDA.n4 GNDA.t35 34.8005
R711 GNDA.n4 GNDA.t13 34.8005
R712 GNDA.n5 GNDA.t42 34.8005
R713 GNDA.n5 GNDA.t3 34.8005
R714 GNDA.n6 GNDA.t11 34.8005
R715 GNDA.n6 GNDA.t22 34.8005
R716 GNDA.n7 GNDA.t102 34.8005
R717 GNDA.n7 GNDA.t28 34.8005
R718 GNDA.t44 GNDA.t39 34.6372
R719 GNDA.t54 GNDA.t99 27.8234
R720 GNDA.n67 GNDA.n14 26.5914
R721 GNDA.n27 GNDA.n14 26.5914
R722 GNDA.n70 GNDA.n69 26.5914
R723 GNDA.n71 GNDA.n70 26.5914
R724 GNDA.n62 GNDA.t17 24.9844
R725 GNDA.t93 GNDA.t45 23.2809
R726 GNDA.t82 GNDA.t74 18.7384
R727 GNDA.n15 GNDA.t96 17.4005
R728 GNDA.n15 GNDA.t1 17.4005
R729 GNDA.n39 GNDA.t49 14.6469
R730 GNDA.n40 GNDA.t51 14.6469
R731 GNDA.n43 GNDA.t56 14.6469
R732 GNDA.n44 GNDA.t57 14.6469
R733 GNDA.n38 GNDA.n21 13.591
R734 GNDA.n41 GNDA.n40 12.1713
R735 GNDA.n39 GNDA.n38 12.1713
R736 GNDA.n45 GNDA.n44 12.1713
R737 GNDA.n43 GNDA.n33 12.1713
R738 GNDA.n65 GNDA.t110 11.7433
R739 GNDA.n73 GNDA.n72 11.4546
R740 GNDA.t52 GNDA.t111 10.789
R741 GNDA.n46 GNDA.n45 10.5738
R742 GNDA.n37 GNDA.n21 9.78498
R743 GNDA.n47 GNDA.n46 9.78498
R744 GNDA.n13 GNDA.n11 9.7505
R745 GNDA.n26 GNDA.n11 9.7505
R746 GNDA.n68 GNDA.n12 9.7505
R747 GNDA.n26 GNDA.n12 9.7505
R748 GNDA.n63 GNDA.n62 9.43931
R749 GNDA.n20 GNDA.n18 9.28621
R750 GNDA.n58 GNDA.n19 9.28621
R751 GNDA.n25 GNDA.n19 9.28621
R752 GNDA.t78 GNDA.t55 9.08554
R753 GNDA.n67 GNDA.n66 8.05327
R754 GNDA.n37 GNDA.n36 7.39059
R755 GNDA GNDA.n76 5.99188
R756 GNDA.n63 GNDA.n16 5.84317
R757 GNDA.n56 GNDA.n30 5.13208
R758 GNDA.n30 GNDA.n29 5.13208
R759 GNDA.n66 GNDA.n65 4.94878
R760 GNDA.n60 GNDA.n59 4.43232
R761 GNDA.n61 GNDA.n60 4.43232
R762 GNDA.n23 GNDA.n17 4.43232
R763 GNDA.n61 GNDA.n17 4.43232
R764 GNDA.n41 GNDA.n37 3.80653
R765 GNDA.n33 GNDA.n22 3.78283
R766 GNDA.n45 GNDA.n42 3.78283
R767 GNDA.n40 GNDA.n39 3.5755
R768 GNDA.n44 GNDA.n43 3.5755
R769 GNDA GNDA.n1 3.13843
R770 GNDA.n48 GNDA.n47 2.78283
R771 GNDA.n49 GNDA.n48 2.40136
R772 GNDA.n9 GNDA.n8 2.21602
R773 GNDA.n76 GNDA.n75 2.21602
R774 GNDA.n50 GNDA.n49 2.21602
R775 GNDA.n53 GNDA.n1 2.21602
R776 GNDA.n64 GNDA.n63 2.21386
R777 GNDA.n75 GNDA.n74 1.97464
R778 GNDA.n54 GNDA.n53 1.97464
R779 GNDA.n73 GNDA.n10 1.68153
R780 GNDA.n35 GNDA.n34 1.39705
R781 GNDA.n55 GNDA.n50 1.09748
R782 GNDA.n65 GNDA.n64 1.05438
R783 GNDA.n55 GNDA.n54 0.877655
R784 GNDA.n47 GNDA.n33 0.789293
R785 GNDA.n38 GNDA.n22 0.765586
R786 GNDA.n42 GNDA.n41 0.765586
R787 GNDA.n34 GNDA.n16 0.733259
R788 GNDA.t99 GNDA.t72 0.568315
R789 GNDA.n10 GNDA.n9 0.207397
R790 GNDA.n42 GNDA.n20 0.1555
R791 GNDA.n58 GNDA.n22 0.1555
R792 GNDA.n74 GNDA.n73 0.0867069
R793 GNDA.n56 GNDA.n55 0.0866111
R794 GNDA.n59 GNDA.n21 0.0749
R795 GNDA.n46 GNDA.n23 0.0749
R796 GNDA.n36 GNDA.n35 0.0694655
R797 a_5801_1601.t0 a_5801_1601.t1 50.4005
R798 a_5659_1601.t0 a_5659_1601.t1 50.4005
R799 a_5517_1601.t0 a_5517_1601.t1 50.4005
R800 a_5375_1601.t0 a_5375_1601.t1 50.4005
R801 a_5233_1601.t0 a_5233_1601.t1 50.4005
R802 a_5091_1601.t0 a_5091_1601.t1 50.4005
R803 a_4949_1601.t0 a_4949_1601.t1 50.4005
R804 a_16674_4519.t0 a_16674_4519.t1 497.577
R805 a_16366_4519.t0 a_16366_4519.t1 497.577
R806 a_16058_4519.t0 a_16058_4519.t1 497.577
R807 a_15750_4519.t0 a_15750_4519.t1 497.577
R808 a_15442_4519.t0 a_15442_4519.t1 497.577
R809 a_16520_6577.t0 a_16520_6577.t1 497.577
R810 a_16212_6577.t0 a_16212_6577.t1 497.577
R811 a_15904_6577.t0 a_15904_6577.t1 497.577
R812 a_15596_6577.t0 a_15596_6577.t1 497.577
R813 a_14506_4519.t0 a_14506_4519.t1 1.69014
R814 a_14128_6329.t0 a_14128_6329.t1 21.2079
R815 a_13750_4519.t0 a_13750_4519.t1 1.69014
R816 a_13372_6329.t0 a_13372_6329.t1 21.2079
R817 a_12994_4519.t0 a_12994_4519.t1 1.69014
R818 a_12616_6329.t0 a_12616_6329.t1 21.2079
R819 a_12238_4519.t0 a_12238_4519.t1 1.69014
R820 a_11860_6329.t0 a_11860_6329.t1 21.2079
R821 a_11104_4519.t0 a_11104_4519.t1 1.69014
R822 a_10726_6199.t0 a_10726_6199.t1 21.2079
R823 a_10348_4519.t0 a_10348_4519.t1 1.69014
R824 a_9970_6199.t0 a_9970_6199.t1 21.2079
R825 a_9592_4519.t0 a_9592_4519.t1 1.69014
R826 a_9214_6199.t0 a_9214_6199.t1 21.2079
R827 a_8836_4519.t0 a_8836_4519.t1 1.69014
R828 net12.n1 net12.t0 17.2604
R829 net12.n9 net12.t3 17.2604
R830 net12.n6 net12.t13 13.9208
R831 net12.n14 net12.t9 13.9208
R832 net12.n3 net12.t15 13.6854
R833 net12.n2 net12.t4 13.6854
R834 net12.n11 net12.t5 13.6854
R835 net12.n10 net12.t14 13.6854
R836 net12.n5 net12.n4 11.9454
R837 net12.n1 net12.n0 11.9454
R838 net12.n13 net12.n12 11.9454
R839 net12.n9 net12.n8 11.9454
R840 net12.n7 net12.t16 9.71497
R841 net12.n3 net12.n2 4.04217
R842 net12.n11 net12.n10 4.04217
R843 net12.n2 net12.n1 3.5755
R844 net12.n5 net12.n3 3.5755
R845 net12.n10 net12.n9 3.5755
R846 net12.n13 net12.n11 3.5755
R847 net12.n15 net12.n14 3.4105
R848 net12.n7 net12.n6 3.4105
R849 net12.n6 net12.n5 3.34008
R850 net12.n14 net12.n13 3.34008
R851 net12.n4 net12.t10 1.7405
R852 net12.n4 net12.t1 1.7405
R853 net12.n0 net12.t6 1.7405
R854 net12.n0 net12.t12 1.7405
R855 net12.n12 net12.t8 1.7405
R856 net12.n12 net12.t7 1.7405
R857 net12.n8 net12.t11 1.7405
R858 net12.n8 net12.t2 1.7405
R859 net12.n15 net12.n7 1.24012
R860 net12 net12.n15 0.01225
R861 net2.n0 net2.t2 34.8005
R862 net2.n0 net2.t0 34.8005
R863 net2.n1 net2.n0 203.435
R864 net2.n35 net2.n1 8.50633
R865 net2 net2.n34 0.01225
R866 net2.n34 net2.n35 0.586825
R867 net2.n35 net2.n31 0.213175
R868 net2.n31 net2.n28 0.763662
R869 net2.n28 net2.n21 0.567438
R870 net2.n21 net2.n14 0.5645
R871 net2.n34 net2.n33 10.4147
R872 net2.n33 net2.n32 199.618
R873 net2.n32 net2.t36 34.8005
R874 net2.n32 net2.t34 34.8005
R875 net2.n33 net2.t35 238.234
R876 net2.n31 net2.n30 10.3605
R877 net2.n30 net2.t32 233.84
R878 net2.n30 net2.n29 200.495
R879 net2.n29 net2.t1 34.8005
R880 net2.n29 net2.t33 34.8005
R881 net2.n26 net2.n24 3.81717
R882 net2.n27 net2.n26 3.81717
R883 net2.n28 net2.n27 4.68967
R884 net2.n27 net2.t6 66.1498
R885 net2.n26 net2.n25 59.0085
R886 net2.n25 net2.t10 7.14175
R887 net2.n25 net2.t22 7.14175
R888 net2.n24 net2.n23 59.0085
R889 net2.n23 net2.t18 7.14175
R890 net2.n23 net2.t5 7.14175
R891 net2.n24 net2.n22 62.8252
R892 net2.n22 net2.t25 7.14175
R893 net2.n22 net2.t23 7.14175
R894 net2.n18 net2.n16 3.81717
R895 net2.n20 net2.n18 3.81717
R896 net2.n21 net2.n20 6.598
R897 net2.n20 net2.n19 59.0085
R898 net2.n19 net2.t20 7.14175
R899 net2.n19 net2.t17 7.14175
R900 net2.n18 net2.n17 59.0085
R901 net2.n17 net2.t13 7.14175
R902 net2.n17 net2.t11 7.14175
R903 net2.n16 net2.n15 59.0085
R904 net2.n15 net2.t24 7.14175
R905 net2.n15 net2.t26 7.14175
R906 net2.n16 net2.t28 69.9665
R907 net2.n11 net2.n9 3.81717
R908 net2.n13 net2.n11 3.81717
R909 net2.n14 net2.n13 6.598
R910 net2.n13 net2.n12 59.0085
R911 net2.n12 net2.t7 7.14175
R912 net2.n12 net2.t31 7.14175
R913 net2.n11 net2.n10 59.0085
R914 net2.n10 net2.t9 7.14175
R915 net2.n10 net2.t30 7.14175
R916 net2.n9 net2.n8 59.0085
R917 net2.n8 net2.t14 7.14175
R918 net2.n8 net2.t12 7.14175
R919 net2.n9 net2.t15 69.9665
R920 net2.n6 net2.n4 3.81717
R921 net2.n7 net2.n6 3.81717
R922 net2.n14 net2.n7 5.2566
R923 net2.n7 net2.t8 66.1498
R924 net2.n6 net2.n5 59.0085
R925 net2.n5 net2.t16 7.14175
R926 net2.n5 net2.t4 7.14175
R927 net2.n4 net2.n3 59.0085
R928 net2.n3 net2.t19 7.14175
R929 net2.n3 net2.t29 7.14175
R930 net2.n4 net2.n2 62.8252
R931 net2.n2 net2.t27 7.14175
R932 net2.n2 net2.t21 7.14175
R933 net2.n1 net2.t3 234.417
R934 net1.n0 net1.t6 34.8005
R935 net1.n0 net1.t0 34.8005
R936 net1.n1 net1.n0 203.147
R937 net1.n35 net1.n1 7.96467
R938 net1 net1.n34 0.01225
R939 net1.n34 net1.n35 0.445825
R940 net1.n35 net1.n31 0.213175
R941 net1.n31 net1.n28 0.599162
R942 net1.n28 net1.n21 0.567438
R943 net1.n21 net1.n14 0.5645
R944 net1.n34 net1.n33 9.873
R945 net1.n33 net1.t1 237.946
R946 net1.n33 net1.n32 199.329
R947 net1.n32 net1.t36 34.8005
R948 net1.n32 net1.t3 34.8005
R949 net1.n31 net1.n29 9.81883
R950 net1.n29 net1.n30 1.1255
R951 net1.n30 net1.t35 234.787
R952 net1.n30 net1.t5 234.13
R953 net1.n29 net1.t4 234.13
R954 net1.n28 net1.n22 4.148
R955 net1.n22 net1.n24 3.81717
R956 net1.n24 net1.n26 3.81717
R957 net1.n26 net1.n27 62.8252
R958 net1.n27 net1.t27 7.14175
R959 net1.n27 net1.t20 7.14175
R960 net1.n26 net1.n25 59.0085
R961 net1.n25 net1.t9 7.14175
R962 net1.n25 net1.t29 7.14175
R963 net1.n24 net1.n23 59.0085
R964 net1.n23 net1.t22 7.14175
R965 net1.n23 net1.t15 7.14175
R966 net1.n22 net1.t30 66.1498
R967 net1.n21 net1.n16 6.05633
R968 net1.n16 net1.n18 3.81717
R969 net1.n18 net1.n20 3.81717
R970 net1.n20 net1.t28 69.9665
R971 net1.n20 net1.n19 59.0085
R972 net1.n19 net1.t34 7.14175
R973 net1.n19 net1.t32 7.14175
R974 net1.n18 net1.n17 59.0085
R975 net1.n17 net1.t16 7.14175
R976 net1.n17 net1.t19 7.14175
R977 net1.n16 net1.n15 59.0085
R978 net1.n15 net1.t24 7.14175
R979 net1.n15 net1.t12 7.14175
R980 net1.n14 net1.n9 6.05633
R981 net1.n9 net1.n11 3.81717
R982 net1.n11 net1.n13 3.81717
R983 net1.n13 net1.t31 69.9665
R984 net1.n13 net1.n12 59.0085
R985 net1.n12 net1.t21 7.14175
R986 net1.n12 net1.t10 7.14175
R987 net1.n11 net1.n10 59.0085
R988 net1.n10 net1.t23 7.14175
R989 net1.n10 net1.t25 7.14175
R990 net1.n9 net1.n8 59.0085
R991 net1.n8 net1.t11 7.14175
R992 net1.n8 net1.t7 7.14175
R993 net1.n14 net1.n2 4.71494
R994 net1.n2 net1.n4 3.81717
R995 net1.n4 net1.n6 3.81717
R996 net1.n6 net1.n7 62.8252
R997 net1.n7 net1.t33 7.14175
R998 net1.n7 net1.t8 7.14175
R999 net1.n6 net1.n5 59.0085
R1000 net1.n5 net1.t17 7.14175
R1001 net1.n5 net1.t14 7.14175
R1002 net1.n4 net1.n3 59.0085
R1003 net1.n3 net1.t13 7.14175
R1004 net1.n3 net1.t18 7.14175
R1005 net1.n2 net1.t26 66.1498
R1006 net1.n1 net1.t2 234.13
R1007 a_8458_6199.t0 a_8458_6199.t1 21.2079
R1008 a_16520_7509.t0 a_16520_7509.t1 443.675
R1009 net6.n0 net6.t0 235.75
R1010 net6.n22 net6.n2 3.4105
R1011 net6.n2 net6.n0 3.09633
R1012 net6.n2 net6.n1 3.09633
R1013 net6.n17 net6.n16 3.4105
R1014 net6.n21 net6.n20 3.4105
R1015 net6 net6.n22 0.01225
R1016 net6.n22 net6.n21 0.304825
R1017 net6.n21 net6.n17 3.33985
R1018 net6.n17 net6.n9 3.79825
R1019 net6.n20 net6.n18 3.09633
R1020 net6.n20 net6.n19 3.09633
R1021 net6.n19 net6.t1 235.75
R1022 net6.n19 net6.t2 233.84
R1023 net6.n18 net6.t13 233.84
R1024 net6.n18 net6.t23 235.75
R1025 net6.n16 net6.n12 0.954667
R1026 net6.n16 net6.n14 0.954667
R1027 net6.n14 net6.n15 34.166
R1028 net6.n15 net6.t6 6.9605
R1029 net6.n15 net6.t16 6.9605
R1030 net6.n14 net6.n13 32.2576
R1031 net6.n13 net6.t17 6.9605
R1032 net6.n13 net6.t8 6.9605
R1033 net6.n12 net6.n11 32.2576
R1034 net6.n11 net6.t10 6.9605
R1035 net6.n11 net6.t21 6.9605
R1036 net6.n12 net6.n10 34.166
R1037 net6.n10 net6.t19 6.9605
R1038 net6.n10 net6.t11 6.9605
R1039 net6.n9 net6.n5 0.954667
R1040 net6.n9 net6.n7 0.954667
R1041 net6.n7 net6.n8 34.166
R1042 net6.n8 net6.t18 6.9605
R1043 net6.n8 net6.t7 6.9605
R1044 net6.n7 net6.n6 32.2576
R1045 net6.n6 net6.t12 6.9605
R1046 net6.n6 net6.t20 6.9605
R1047 net6.n5 net6.n4 32.2576
R1048 net6.n4 net6.t22 6.9605
R1049 net6.n4 net6.t9 6.9605
R1050 net6.n5 net6.n3 34.166
R1051 net6.n3 net6.t5 6.9605
R1052 net6.n3 net6.t15 6.9605
R1053 net6.n1 net6.t3 235.75
R1054 net6.n1 net6.t4 233.84
R1055 net6.n0 net6.t14 233.84
R1056 net15 net15.t1 660.438
R1057 net15 net15.t0 19.3399
R1058 VSTRP_OUT.t0 VSTRP_OUT.n0 228.577
R1059 VSTRP_OUT.n1 VSTRP_OUT.n0 4.5005
R1060 VSTRP_OUT VSTRP_OUT.n2 0.0421667
R1061 VSTRP_OUT.n2 VSTRP_OUT.n1 1.93592
R1062 VSTRP_OUT.n1 VSTRP_OUT.t2 233.785
R1063 VSTRP_OUT.n2 VSTRP_OUT.t3 248.829
R1064 VSTRP_OUT.n0 VSTRP_OUT.t1 85.1739
R1065 EN_B.t0 EN_B.n4 83.7172
R1066 EN_B.n0 EN_B.n4 4.86108
R1067 EN_B EN_B.n2 0.0421667
R1068 EN_B.n2 EN_B.n3 7.688
R1069 EN_B.n3 EN_B.n0 5.68592
R1070 EN_B.n3 EN_B.t2 323.961
R1071 EN_B.n2 EN_B.n1 166.62
R1072 EN_B.n1 EN_B.t3 49.078
R1073 EN_B.n1 EN_B.t4 248.131
R1074 EN_B.n0 EN_B.t5 467.546
R1075 EN_B.n4 EN_B.t1 230.032
R1076 net14.t0 net14.n0 228.864
R1077 net14.n1 net14.n0 4.5005
R1078 net14 net14.n1 0.0421667
R1079 net14.n1 net14.n2 6.14425
R1080 net14.n2 net14.t2 445.166
R1081 net14.n2 net14.t3 459.873
R1082 net14.n0 net14.t1 84.8854
R1083 VSTRP_IP.t5 VSTRP_IP 237.804
R1084 VSTRP_IP VSTRP_IP.n7 3.42225
R1085 VSTRP_IP.n3 VSTRP_IP.n1 1.90883
R1086 VSTRP_IP.n5 VSTRP_IP.n3 1.90883
R1087 VSTRP_IP.n7 VSTRP_IP.n5 2.74008
R1088 VSTRP_IP.n7 VSTRP_IP.n6 5.78383
R1089 VSTRP_IP.n6 VSTRP_IP.t8 444.877
R1090 VSTRP_IP.n6 VSTRP_IP.t9 460.161
R1091 VSTRP_IP.n5 VSTRP_IP.n4 105.038
R1092 VSTRP_IP.n4 VSTRP_IP.t1 14.283
R1093 VSTRP_IP.n4 VSTRP_IP.t7 14.283
R1094 VSTRP_IP.n3 VSTRP_IP.n2 105.038
R1095 VSTRP_IP.n2 VSTRP_IP.t2 14.283
R1096 VSTRP_IP.n2 VSTRP_IP.t3 14.283
R1097 VSTRP_IP.n1 VSTRP_IP.n0 105.038
R1098 VSTRP_IP.n0 VSTRP_IP.t4 14.283
R1099 VSTRP_IP.n0 VSTRP_IP.t0 14.283
R1100 VSTRP_IP.n1 VSTRP_IP.t6 121.23
R1101 net8.n0 net8.t2 219.8
R1102 net8.n0 net8.n15 33.1299
R1103 net8.n5 net8.n4 41.285
R1104 net8.n6 net8.n5 51.3808
R1105 net8.n7 net8.n6 41.285
R1106 net8.n8 net8.n7 41.285
R1107 net8.n9 net8.n8 41.285
R1108 net8.n10 net8.n9 41.285
R1109 net8.n11 net8.n10 41.285
R1110 net8.n12 net8.n11 51.3808
R1111 net8.n13 net8.n12 41.285
R1112 net8.n15 net8.n13 38.4906
R1113 net8.n15 net8.n14 20.6428
R1114 net8.n14 net8.t16 158.21
R1115 net8.n14 net8.t5 43.053
R1116 net8.n13 net8.t6 43.053
R1117 net8.n12 net8.t7 43.053
R1118 net8.n11 net8.t8 43.053
R1119 net8.n10 net8.t9 43.053
R1120 net8.n9 net8.t10 43.053
R1121 net8.n8 net8.t11 43.053
R1122 net8.n7 net8.t12 43.053
R1123 net8.n6 net8.t13 43.053
R1124 net8.n5 net8.t14 43.053
R1125 net8.n4 net8.t15 43.053
R1126 net8.n14 net8.t1 43.053
R1127 net8.n13 net8.t17 43.053
R1128 net8.n12 net8.t18 43.053
R1129 net8.n11 net8.t19 43.053
R1130 net8.n10 net8.t20 43.053
R1131 net8.n9 net8.t21 43.053
R1132 net8.n8 net8.t22 43.053
R1133 net8.n7 net8.t23 43.053
R1134 net8.n6 net8.t24 43.053
R1135 net8.n5 net8.t25 43.053
R1136 net8.n4 net8.t26 43.053
R1137 net8.n3 net8.n0 18.4509
R1138 net8 net8.n3 0.01225
R1139 net8.n2 net8.n1 4.5005
R1140 net8.n3 net8.n2 11.648
R1141 net8.n2 net8.t0 120.653
R1142 net8.n1 net8.t4 85.1386
R1143 net8.n1 net8.t3 114.209
R1144 a_5881_8265.t0 a_5881_8265.t1 82.7405
R1145 a_5739_8265.t0 a_5739_8265.t1 82.7405
R1146 VBP_CASC.n20 VBP_CASC.t0 238.207
R1147 VBP_CASC VBP_CASC.n20 0.01225
R1148 VBP_CASC.n20 VBP_CASC.n0 16.5776
R1149 VBP_CASC.n0 VBP_CASC.n19 70.3503
R1150 VBP_CASC.n2 VBP_CASC.n1 59.4829
R1151 VBP_CASC.n3 VBP_CASC.n2 59.4829
R1152 VBP_CASC.n4 VBP_CASC.n3 101.647
R1153 VBP_CASC.n5 VBP_CASC.n4 59.4829
R1154 VBP_CASC.n6 VBP_CASC.n5 59.4829
R1155 VBP_CASC.n7 VBP_CASC.n6 59.4829
R1156 VBP_CASC.n8 VBP_CASC.n7 101.647
R1157 VBP_CASC.n9 VBP_CASC.n8 59.4829
R1158 VBP_CASC.n10 VBP_CASC.n9 59.4829
R1159 VBP_CASC.n11 VBP_CASC.n10 59.4829
R1160 VBP_CASC.n12 VBP_CASC.n11 101.647
R1161 VBP_CASC.n13 VBP_CASC.n12 59.4829
R1162 VBP_CASC.n14 VBP_CASC.n13 59.4829
R1163 VBP_CASC.n15 VBP_CASC.n14 59.4829
R1164 VBP_CASC.n16 VBP_CASC.n15 126.495
R1165 VBP_CASC.n17 VBP_CASC.n16 53.4593
R1166 VBP_CASC.n18 VBP_CASC.n17 53.4593
R1167 VBP_CASC.n19 VBP_CASC.n18 54.9652
R1168 VBP_CASC.n18 VBP_CASC.t1 206.948
R1169 VBP_CASC.n17 VBP_CASC.t4 206.948
R1170 VBP_CASC.n16 VBP_CASC.t5 206.948
R1171 VBP_CASC.n15 VBP_CASC.t6 206.948
R1172 VBP_CASC.n14 VBP_CASC.t7 206.948
R1173 VBP_CASC.n13 VBP_CASC.t8 206.948
R1174 VBP_CASC.n12 VBP_CASC.t9 206.948
R1175 VBP_CASC.n11 VBP_CASC.t10 206.948
R1176 VBP_CASC.n10 VBP_CASC.t11 206.948
R1177 VBP_CASC.n9 VBP_CASC.t12 206.948
R1178 VBP_CASC.n8 VBP_CASC.t13 206.948
R1179 VBP_CASC.n7 VBP_CASC.t14 206.948
R1180 VBP_CASC.n6 VBP_CASC.t15 206.948
R1181 VBP_CASC.n5 VBP_CASC.t16 206.948
R1182 VBP_CASC.n4 VBP_CASC.t17 206.948
R1183 VBP_CASC.n3 VBP_CASC.t18 206.948
R1184 VBP_CASC.n2 VBP_CASC.t19 206.948
R1185 VBP_CASC.n1 VBP_CASC.t20 206.948
R1186 VBP_CASC.n1 VBP_CASC.t21 266.43
R1187 VBP_CASC.n19 VBP_CASC.t2 642.13
R1188 VBP_CASC.n0 VBP_CASC.t3 111.784
R1189 VBP_TOP.t18 VBP_TOP.n0 651.883
R1190 VBP_TOP.n0 VBP_TOP.n16 2.90347
R1191 VBP_TOP.n16 VBP_TOP.n26 92.9887
R1192 VBP_TOP.n26 VBP_TOP.n17 272.188
R1193 VBP_TOP.n26 VBP_TOP.n18 86.2123
R1194 VBP_TOP.n18 VBP_TOP.n19 172.424
R1195 VBP_TOP.n19 VBP_TOP.n20 216.847
R1196 VBP_TOP.n20 VBP_TOP.n21 172.424
R1197 VBP_TOP.n21 VBP_TOP.n22 172.424
R1198 VBP_TOP.n22 VBP_TOP.n23 172.424
R1199 VBP_TOP.n23 VBP_TOP.n24 172.424
R1200 VBP_TOP.n24 VBP_TOP.n25 172.424
R1201 VBP_TOP.n25 VBP_TOP.t19 234.637
R1202 VBP_TOP.n25 VBP_TOP.t20 62.2125
R1203 VBP_TOP.n24 VBP_TOP.t21 62.2125
R1204 VBP_TOP.n23 VBP_TOP.t22 62.2125
R1205 VBP_TOP.n22 VBP_TOP.t23 62.2125
R1206 VBP_TOP.n21 VBP_TOP.t24 62.2125
R1207 VBP_TOP.n20 VBP_TOP.t25 62.2125
R1208 VBP_TOP.n19 VBP_TOP.t26 62.2125
R1209 VBP_TOP.n18 VBP_TOP.t0 62.2125
R1210 VBP_TOP.n17 VBP_TOP.t27 62.2125
R1211 VBP_TOP.n17 VBP_TOP.t28 234.637
R1212 VBP_TOP.n16 VBP_TOP.t1 111.784
R1213 VBP_TOP VBP_TOP.n0 8.08267
R1214 VBP_TOP.n8 VBP_TOP.n7 3.4105
R1215 VBP_TOP.n8 VBP_TOP.n15 4.65012
R1216 VBP_TOP VBP_TOP.n8 2.76175
R1217 VBP_TOP.n15 VBP_TOP.n11 1.79425
R1218 VBP_TOP.n11 VBP_TOP.n13 7.61717
R1219 VBP_TOP.n13 VBP_TOP.n14 15.0396
R1220 VBP_TOP.n14 VBP_TOP.t16 1.7405
R1221 VBP_TOP.n14 VBP_TOP.t17 1.7405
R1222 VBP_TOP.n13 VBP_TOP.n12 11.4646
R1223 VBP_TOP.n12 VBP_TOP.t14 1.7405
R1224 VBP_TOP.n12 VBP_TOP.t15 1.7405
R1225 VBP_TOP.n11 VBP_TOP.n10 11.4646
R1226 VBP_TOP.n10 VBP_TOP.t12 1.7405
R1227 VBP_TOP.n10 VBP_TOP.t13 1.7405
R1228 VBP_TOP.n15 VBP_TOP.n9 13.2459
R1229 VBP_TOP.n9 VBP_TOP.t10 1.7405
R1230 VBP_TOP.n9 VBP_TOP.t11 1.7405
R1231 VBP_TOP.n7 VBP_TOP.n3 1.79425
R1232 VBP_TOP.n3 VBP_TOP.n5 7.61717
R1233 VBP_TOP.n5 VBP_TOP.n6 15.0396
R1234 VBP_TOP.n6 VBP_TOP.t8 1.7405
R1235 VBP_TOP.n6 VBP_TOP.t9 1.7405
R1236 VBP_TOP.n5 VBP_TOP.n4 11.4646
R1237 VBP_TOP.n4 VBP_TOP.t6 1.7405
R1238 VBP_TOP.n4 VBP_TOP.t7 1.7405
R1239 VBP_TOP.n3 VBP_TOP.n2 11.4646
R1240 VBP_TOP.n2 VBP_TOP.t4 1.7405
R1241 VBP_TOP.n2 VBP_TOP.t5 1.7405
R1242 VBP_TOP.n7 VBP_TOP.n1 13.2459
R1243 VBP_TOP.n1 VBP_TOP.t2 1.7405
R1244 VBP_TOP.n1 VBP_TOP.t3 1.7405
R1245 VBN_CASC.t1 VBN_CASC.n0 219.8
R1246 VBN_CASC.n4 VBN_CASC.n3 59.4829
R1247 VBN_CASC.n5 VBN_CASC.n4 101.647
R1248 VBN_CASC.n6 VBN_CASC.n5 59.4829
R1249 VBN_CASC.n7 VBN_CASC.n6 101.647
R1250 VBN_CASC.n8 VBN_CASC.n7 126.495
R1251 VBN_CASC.n9 VBN_CASC.n8 53.4593
R1252 VBN_CASC.n10 VBN_CASC.n9 53.4593
R1253 VBN_CASC.n11 VBN_CASC.n10 53.4593
R1254 VBN_CASC.n12 VBN_CASC.n11 53.4593
R1255 VBN_CASC.n13 VBN_CASC.n12 53.4593
R1256 VBN_CASC.n14 VBN_CASC.n13 53.4593
R1257 VBN_CASC.n15 VBN_CASC.n14 53.4593
R1258 VBN_CASC.n0 VBN_CASC.n15 62.8711
R1259 VBN_CASC.n15 VBN_CASC.t0 202.611
R1260 VBN_CASC.n14 VBN_CASC.t4 202.611
R1261 VBN_CASC.n13 VBN_CASC.t5 202.611
R1262 VBN_CASC.n12 VBN_CASC.t6 202.611
R1263 VBN_CASC.n11 VBN_CASC.t7 202.611
R1264 VBN_CASC.n10 VBN_CASC.t8 202.611
R1265 VBN_CASC.n9 VBN_CASC.t9 202.611
R1266 VBN_CASC.n8 VBN_CASC.t10 202.611
R1267 VBN_CASC.n7 VBN_CASC.t11 202.611
R1268 VBN_CASC.n6 VBN_CASC.t12 202.611
R1269 VBN_CASC.n5 VBN_CASC.t13 202.611
R1270 VBN_CASC.n4 VBN_CASC.t14 202.611
R1271 VBN_CASC.n3 VBN_CASC.t15 202.611
R1272 VBN_CASC.n3 VBN_CASC.t16 304.257
R1273 VBN_CASC.n2 VBN_CASC.n0 19.0477
R1274 VBN_CASC VBN_CASC.n2 0.01225
R1275 VBN_CASC.n2 VBN_CASC.n1 3.54195
R1276 VBN_CASC.n1 VBN_CASC.t3 98.5398
R1277 VBN_CASC.n1 VBN_CASC.t2 132.617
R1278 net7.n0 net7.t58 7.14175
R1279 net7.n0 net7.t30 7.14175
R1280 net7.n1 net7.n0 58.5278
R1281 net7.n6 net7.n4 1.90883
R1282 net7.n8 net7.n6 1.90883
R1283 net7.n10 net7.n8 1.90883
R1284 net7.n12 net7.n10 1.90883
R1285 net7.n1 net7.n12 1.90883
R1286 net7.n62 net7.n1 6.3105
R1287 net7 net7.n62 0.01225
R1288 net7.n62 net7.n61 0.567438
R1289 net7.n61 net7.n47 0.5645
R1290 net7.n47 net7.n33 0.567438
R1291 net7.n52 net7.n50 1.90883
R1292 net7.n54 net7.n52 1.90883
R1293 net7.n56 net7.n54 1.90883
R1294 net7.n58 net7.n56 1.90883
R1295 net7.n60 net7.n58 1.90883
R1296 net7.n61 net7.n60 6.3105
R1297 net7.n60 net7.n59 58.5278
R1298 net7.n59 net7.t23 7.14175
R1299 net7.n59 net7.t51 7.14175
R1300 net7.n58 net7.n57 58.5278
R1301 net7.n57 net7.t50 7.14175
R1302 net7.n57 net7.t22 7.14175
R1303 net7.n56 net7.n55 58.5278
R1304 net7.n55 net7.t21 7.14175
R1305 net7.n55 net7.t49 7.14175
R1306 net7.n54 net7.n53 58.5278
R1307 net7.n53 net7.t48 7.14175
R1308 net7.n53 net7.t20 7.14175
R1309 net7.n52 net7.n51 58.5278
R1310 net7.n51 net7.t19 7.14175
R1311 net7.n51 net7.t47 7.14175
R1312 net7.n50 net7.n49 58.5278
R1313 net7.n49 net7.t46 7.14175
R1314 net7.n49 net7.t18 7.14175
R1315 net7.n50 net7.n48 60.4361
R1316 net7.n48 net7.t17 7.14175
R1317 net7.n48 net7.t45 7.14175
R1318 net7.n38 net7.n36 1.90883
R1319 net7.n40 net7.n38 1.90883
R1320 net7.n42 net7.n40 1.90883
R1321 net7.n44 net7.n42 1.90883
R1322 net7.n46 net7.n44 1.90883
R1323 net7.n47 net7.n46 6.3105
R1324 net7.n46 net7.n45 58.5278
R1325 net7.n45 net7.t16 7.14175
R1326 net7.n45 net7.t44 7.14175
R1327 net7.n44 net7.n43 58.5278
R1328 net7.n43 net7.t43 7.14175
R1329 net7.n43 net7.t15 7.14175
R1330 net7.n42 net7.n41 58.5278
R1331 net7.n41 net7.t14 7.14175
R1332 net7.n41 net7.t42 7.14175
R1333 net7.n40 net7.n39 58.5278
R1334 net7.n39 net7.t41 7.14175
R1335 net7.n39 net7.t13 7.14175
R1336 net7.n38 net7.n37 58.5278
R1337 net7.n37 net7.t12 7.14175
R1338 net7.n37 net7.t40 7.14175
R1339 net7.n36 net7.n35 58.5278
R1340 net7.n35 net7.t39 7.14175
R1341 net7.n35 net7.t11 7.14175
R1342 net7.n36 net7.n34 60.4361
R1343 net7.n34 net7.t10 7.14175
R1344 net7.n34 net7.t38 7.14175
R1345 net7.n24 net7.n22 1.90883
R1346 net7.n26 net7.n24 1.90883
R1347 net7.n28 net7.n26 1.90883
R1348 net7.n30 net7.n28 1.90883
R1349 net7.n32 net7.n30 1.90883
R1350 net7.n33 net7.n32 6.3105
R1351 net7.n32 net7.n31 58.5278
R1352 net7.n31 net7.t37 7.14175
R1353 net7.n31 net7.t9 7.14175
R1354 net7.n30 net7.n29 58.5278
R1355 net7.n29 net7.t8 7.14175
R1356 net7.n29 net7.t36 7.14175
R1357 net7.n28 net7.n27 58.5278
R1358 net7.n27 net7.t35 7.14175
R1359 net7.n27 net7.t7 7.14175
R1360 net7.n26 net7.n25 58.5278
R1361 net7.n25 net7.t6 7.14175
R1362 net7.n25 net7.t34 7.14175
R1363 net7.n24 net7.n23 58.5278
R1364 net7.n23 net7.t33 7.14175
R1365 net7.n23 net7.t5 7.14175
R1366 net7.n22 net7.n21 58.5278
R1367 net7.n21 net7.t4 7.14175
R1368 net7.n21 net7.t32 7.14175
R1369 net7.n22 net7.n20 60.4361
R1370 net7.n20 net7.t31 7.14175
R1371 net7.n20 net7.t3 7.14175
R1372 net7.n33 net7.n13 5.9925
R1373 net7.n13 net7.n15 1.90883
R1374 net7.n15 net7.n16 1.90883
R1375 net7.n16 net7.n17 2.4005
R1376 net7.n17 net7.n19 1.90883
R1377 net7.n19 net7.t1 120.34
R1378 net7.n19 net7.n18 104.148
R1379 net7.n18 net7.t59 14.283
R1380 net7.n18 net7.t60 14.283
R1381 net7.n17 net7.t63 118.431
R1382 net7.n16 net7.t0 118.431
R1383 net7.n15 net7.n14 104.148
R1384 net7.n14 net7.t62 14.283
R1385 net7.n14 net7.t61 14.283
R1386 net7.n13 net7.t2 118.431
R1387 net7.n12 net7.n11 58.5278
R1388 net7.n11 net7.t29 7.14175
R1389 net7.n11 net7.t57 7.14175
R1390 net7.n10 net7.n9 58.5278
R1391 net7.n9 net7.t56 7.14175
R1392 net7.n9 net7.t28 7.14175
R1393 net7.n8 net7.n7 58.5278
R1394 net7.n7 net7.t27 7.14175
R1395 net7.n7 net7.t55 7.14175
R1396 net7.n6 net7.n5 58.5278
R1397 net7.n5 net7.t54 7.14175
R1398 net7.n5 net7.t26 7.14175
R1399 net7.n4 net7.n3 58.5278
R1400 net7.n3 net7.t25 7.14175
R1401 net7.n3 net7.t53 7.14175
R1402 net7.n4 net7.n2 60.4361
R1403 net7.n2 net7.t52 7.14175
R1404 net7.n2 net7.t24 7.14175
R1405 net4.t7 net4.n0 656.75
R1406 net4.n4 net4.n3 4.5005
R1407 net4.n9 net4.n7 0.658833
R1408 net4.n4 net4.n9 0.7755
R1409 net4.n11 net4.n4 0.7755
R1410 net4.n0 net4.n11 0.658833
R1411 net4.n6 net4.n0 2.38383
R1412 net4.n15 net4.n6 5.40155
R1413 net4 net4.n19 0.01225
R1414 net4.n19 net4.n15 0.38825
R1415 net4.n19 net4.n18 6.5855
R1416 net4.n18 net4.n17 32.5701
R1417 net4.n17 net4.t18 6.9605
R1418 net4.n17 net4.t19 6.9605
R1419 net4.n18 net4.n16 36.3868
R1420 net4.n16 net4.t16 6.9605
R1421 net4.n16 net4.t17 6.9605
R1422 net4.n14 net4.n13 3.81717
R1423 net4.n15 net4.n14 4.67717
R1424 net4.n14 net4.t15 39.5301
R1425 net4.n13 net4.n12 32.5701
R1426 net4.n12 net4.t13 6.9605
R1427 net4.n12 net4.t14 6.9605
R1428 net4.n13 net4.t12 43.3468
R1429 net4.n11 net4.n10 599.62
R1430 net4.n10 net4.t5 57.1305
R1431 net4.n10 net4.t6 57.1305
R1432 net4.n9 net4.n8 599.62
R1433 net4.n8 net4.t1 57.1305
R1434 net4.n8 net4.t2 57.1305
R1435 net4.n7 net4.t0 656.75
R1436 net4.n6 net4.n5 104.93
R1437 net4.n5 net4.t9 14.283
R1438 net4.n5 net4.t11 14.283
R1439 net4.n3 net4.t4 652.283
R1440 net4.n3 net4.t3 652.283
R1441 net4.n3 net4.n2 100.353
R1442 net4.n2 net4.t21 14.283
R1443 net4.n2 net4.t20 14.283
R1444 net4.n7 net4.n1 107.314
R1445 net4.n1 net4.t8 14.283
R1446 net4.n1 net4.t10 14.283
R1447 net3.n0 net3.t19 6.9605
R1448 net3.n0 net3.t20 6.9605
R1449 net3.n1 net3.n0 32.5701
R1450 net3.n20 net3.n2 5.84383
R1451 net3.n2 net3.n1 3.81717
R1452 net3 net3.n20 0.01225
R1453 net3.n20 net3.n19 0.38825
R1454 net3.n19 net3.n17 7.75217
R1455 net3.n17 net3.n18 36.3868
R1456 net3.n18 net3.t16 6.9605
R1457 net3.n18 net3.t17 6.9605
R1458 net3.n17 net3.n16 32.5701
R1459 net3.n16 net3.t14 6.9605
R1460 net3.n16 net3.t15 6.9605
R1461 net3.n6 net3.n5 4.5005
R1462 net3.n9 net3.n8 4.5005
R1463 net3.n19 net3.n3 4.74214
R1464 net3.n3 net3.n10 2.74217
R1465 net3.n10 net3.n12 0.658833
R1466 net3.n12 net3.n6 0.417167
R1467 net3.n6 net3.n9 3.81717
R1468 net3.n9 net3.n14 0.417167
R1469 net3.n14 net3.n15 0.658833
R1470 net3.n15 net3.t8 656.462
R1471 net3.n14 net3.n13 599.332
R1472 net3.n13 net3.t2 57.1305
R1473 net3.n13 net3.t7 57.1305
R1474 net3.n12 net3.n11 599.332
R1475 net3.n11 net3.t1 57.1305
R1476 net3.n11 net3.t5 57.1305
R1477 net3.n10 net3.t3 656.462
R1478 net3.n15 net3.t11 122.243
R1479 net3.n8 net3.t6 652.111
R1480 net3.n8 net3.n7 100.641
R1481 net3.n7 net3.t12 14.283
R1482 net3.n7 net3.t13 14.283
R1483 net3.n5 net3.t4 652.111
R1484 net3.n5 net3.n4 100.641
R1485 net3.n4 net3.t10 14.283
R1486 net3.n4 net3.t0 14.283
R1487 net3.n3 net3.t9 119.501
R1488 net3.n1 net3.t21 43.3468
R1489 net3.n2 net3.t18 39.5301
R1490 net9.t2 net9.n11 239.114
R1491 net9 net9.n11 0.01225
R1492 net9.n11 net9.n10 15.6272
R1493 net9.n10 net9.t3 125.314
R1494 net9.n10 net9.n0 6.3605
R1495 net9.n0 net9.n9 92.9887
R1496 net9.n2 net9.n1 172.424
R1497 net9.n3 net9.n2 172.424
R1498 net9.n9 net9.n3 130.636
R1499 net9.n9 net9.n4 86.2123
R1500 net9.n4 net9.n5 172.424
R1501 net9.n5 net9.n6 216.847
R1502 net9.n6 net9.n7 172.424
R1503 net9.n7 net9.n8 172.424
R1504 net9.n8 net9.t4 234.637
R1505 net9.n8 net9.t5 62.2125
R1506 net9.n7 net9.t6 62.2125
R1507 net9.n6 net9.t7 62.2125
R1508 net9.n5 net9.t8 62.2125
R1509 net9.n4 net9.t0 62.2125
R1510 net9.n3 net9.t9 62.2125
R1511 net9.n2 net9.t10 62.2125
R1512 net9.n1 net9.t11 62.2125
R1513 net9.n1 net9.t12 234.637
R1514 net9.n0 net9.t1 111.784
R1515 net5.n0 net5.t6 57.1305
R1516 net5.n0 net5.t7 57.1305
R1517 net5.n1 net5.n0 599.617
R1518 net5.n22 net5.n3 8.50633
R1519 net5.n3 net5.n5 0.658833
R1520 net5.n5 net5.n7 3.99217
R1521 net5.n7 net5.n1 0.658833
R1522 net5 net5.n21 0.01225
R1523 net5.n21 net5.n22 3.60305
R1524 net5.n21 net5.n19 9.823
R1525 net5.n19 net5.n20 201.046
R1526 net5.n20 net5.t9 34.8005
R1527 net5.n20 net5.t10 34.8005
R1528 net5.n19 net5.t8 234.062
R1529 net5.n22 net5.n8 469.858
R1530 net5.n8 net5.n9 172.424
R1531 net5.n9 net5.n10 172.424
R1532 net5.n10 net5.n11 172.424
R1533 net5.n11 net5.n12 172.424
R1534 net5.n12 net5.n13 172.424
R1535 net5.n13 net5.n14 172.424
R1536 net5.n14 net5.n15 172.424
R1537 net5.n15 net5.n16 172.424
R1538 net5.n16 net5.n17 172.424
R1539 net5.n17 net5.n18 172.424
R1540 net5.n18 net5.t12 234.637
R1541 net5.n18 net5.t13 62.2125
R1542 net5.n17 net5.t14 62.2125
R1543 net5.n16 net5.t15 62.2125
R1544 net5.n15 net5.t16 62.2125
R1545 net5.n14 net5.t17 62.2125
R1546 net5.n13 net5.t18 62.2125
R1547 net5.n12 net5.t19 62.2125
R1548 net5.n11 net5.t20 62.2125
R1549 net5.n10 net5.t21 62.2125
R1550 net5.n9 net5.t22 62.2125
R1551 net5.n8 net5.t23 62.2125
R1552 net5.n7 net5.n6 599.617
R1553 net5.n6 net5.t4 57.1305
R1554 net5.n6 net5.t5 57.1305
R1555 net5.n5 net5.n4 599.617
R1556 net5.n4 net5.t2 57.1305
R1557 net5.n4 net5.t3 57.1305
R1558 net5.n3 net5.n2 599.617
R1559 net5.n2 net5.t0 57.1305
R1560 net5.n2 net5.t1 57.1305
R1561 net5.n1 net5.t11 125.853
C0 net15 VSTRP_OUT 0.05912f
C1 VOUT net5 2.94184f
C2 net4 VDD 1.95179f
C3 net8 MN_TAIL_BIAS 0.00262f
C4 VBP_CASC VDD 3.75239f
C5 net1 net9 0.11447f
C6 net4 VINP 0.75975f
C7 VOUT net12 0.23962f
C8 net8 VBP_TOP 0.44833f
C9 VBP_CASC VINP 0.17659f
C10 VOUT EN 0.00956f
C11 net7 net5 0.09176f
C12 net8 net9 0.3269f
C13 VBP_CASC net4 0.64592f
C14 net15 net14 0.00438f
C15 net7 net12 0.40655f
C16 VOUT MN_TAIL_BIAS 0.1093f
C17 net7 EN 1.41463f
C18 VOUT VBP_TOP 0.00115f
C19 EN net5 0.47206f
C20 net9 net6 0
C21 net3 VBN_CASC 0.12551f
C22 EN_B VBN_CASC 0.25548f
C23 net15 VDD 0.46803f
C24 net9 VOUT 0.09674f
C25 net7 MN_TAIL_BIAS 0.03228f
C26 net3 VINN 1.04464f
C27 EN_B VINN 0
C28 net7 VBP_TOP 0.06186f
C29 VSTRP_IP net15 0.45271f
C30 MN_TAIL_BIAS net12 18.8581f
C31 VBN_CASC net1 0.33044f
C32 net12 VBP_TOP 6.13805f
C33 net7 net9 4.93703f
C34 net9 net5 0.06576f
C35 MN_TAIL_BIAS EN 0.40134f
C36 EN_B VSTRP_OUT 0.24133f
C37 net1 VINN 3.88093f
C38 EN VBP_TOP 1.22319f
C39 net8 VBN_CASC 0.11955f
C40 net9 net12 0
C41 net9 EN 1.23863f
C42 net8 VINN 0.93096f
C43 MN_TAIL_BIAS VBP_TOP 20.2384f
C44 net3 net2 0.27651f
C45 EN_B net14 0.11446f
C46 VBN_CASC net6 0.05256f
C47 net9 MN_TAIL_BIAS 0.00699f
C48 VBN_CASC VOUT 0.47969f
C49 net9 VBP_TOP 2.3028f
C50 VINN net6 3.10846f
C51 net3 VDD 3.09758f
C52 EN_B VDD 3.61653f
C53 VOUT VINN 0.69124f
C54 net2 net1 7.57349f
C55 net3 VINP 2.76873f
C56 net7 VBN_CASC 0.88994f
C57 VBN_CASC net5 0.57848f
C58 net2 net8 1.27439f
C59 EN_B VSTRP_IP 0.12648f
C60 net3 net4 3.69367f
C61 net7 VINN 11.1751f
C62 net1 VDD 4.34146f
C63 net3 VBP_CASC 0.86825f
C64 VINN net5 0.22516f
C65 net1 VINP 12.3954f
C66 VBN_CASC EN 0.10924f
C67 VINN net12 0.0026f
C68 net8 VDD 2.11014f
C69 net2 net6 1.33724f
C70 net8 VINP 0.16448f
C71 net1 net4 0
C72 VINN EN 0.07552f
C73 VBP_CASC net1 0.13404f
C74 net2 VOUT 3.27829f
C75 VBN_CASC MN_TAIL_BIAS 0.00288f
C76 VBN_CASC VBP_TOP 0.01335f
C77 net8 net4 0
C78 VDD net6 0.13722f
C79 net8 VBP_CASC 3.7608f
C80 VINN MN_TAIL_BIAS 0.00195f
C81 VSTRP_OUT EN 0.239f
C82 VINP net6 3.22026f
C83 VBN_CASC net9 6.04432f
C84 EN_B net15 0.08633f
C85 VOUT VDD 1.20267f
C86 net2 net7 13.1593f
C87 net2 net5 0.27541f
C88 VOUT VINP 0.25941f
C89 net9 VINN 0.35694f
C90 net2 net12 0.00715f
C91 net4 net6 3.39501f
C92 VSTRP_OUT MN_TAIL_BIAS 0.2215f
C93 VBP_CASC net6 0.06823f
C94 VSTRP_OUT VBP_TOP 0.00236f
C95 net4 VOUT 0.46691f
C96 net7 VDD 8.97905f
C97 net14 EN 0.12405f
C98 VBP_CASC VOUT 0.79285f
C99 VDD net5 12.9652f
C100 net7 VINP 10.6061f
C101 VINP net5 1.75037f
C102 VDD net12 0.0342f
C103 net7 VSTRP_IP 0.00915f
C104 VINP net12 0
C105 net2 MN_TAIL_BIAS 0.01193f
C106 VDD EN 4.84469f
C107 net7 net4 0
C108 net2 VBP_TOP 0
C109 net7 VBP_CASC 0.27354f
C110 net4 net5 2.04727f
C111 VBP_CASC net5 0.65889f
C112 VBP_CASC net12 0
C113 net2 net9 0.7148f
C114 VSTRP_IP EN 0.10385f
C115 VDD MN_TAIL_BIAS 1.9398f
C116 net4 EN 0.16096f
C117 VDD VBP_TOP 7.37884f
C118 VBP_CASC EN 0.20212f
C119 VBN_CASC VINN 0.91049f
C120 VSTRP_IP MN_TAIL_BIAS 1.54162f
C121 net9 VDD 8.12339f
C122 VSTRP_IP VBP_TOP 1.1328f
C123 net9 VINP 0.12426f
C124 VBP_CASC MN_TAIL_BIAS 0
C125 VSTRP_IP net9 0.01073f
C126 net3 net1 0.01214f
C127 net4 net9 0.00232f
C128 VBP_CASC net9 3.42609f
C129 net15 EN 0.00135f
C130 net3 net8 0
C131 EN_B net8 0.08622f
C132 net2 VBN_CASC 1.10729f
C133 net15 MN_TAIL_BIAS 0.21057f
C134 net2 VINN 12.0845f
C135 net15 VBP_TOP 0
C136 net3 net6 3.46455f
C137 net8 net1 0.6262f
C138 VBN_CASC VDD 1.70637f
C139 net3 VOUT 0.33982f
C140 EN_B VOUT 0
C141 VBN_CASC VINP 0.67615f
C142 VSTRP_OUT net14 0.8894f
C143 VDD VINN 13.4799f
C144 VINN VINP 20.2339f
C145 net1 net6 4.12887f
C146 VBN_CASC net4 0.93319f
C147 VBN_CASC VBP_CASC 0.10706f
C148 net3 net7 0.02782f
C149 EN_B net7 0.01622f
C150 net1 VOUT 0.45578f
C151 net3 net5 2.27738f
C152 VSTRP_OUT VDD 2.39815f
C153 net4 VINN 2.89852f
C154 net8 net6 1.96582f
C155 VBP_CASC VINN 0.28345f
C156 net8 VOUT 0.53124f
C157 net3 EN 0.21336f
C158 VSTRP_IP VSTRP_OUT 0.12024f
C159 EN_B EN 0.76572f
C160 net7 net1 11.9474f
C161 net1 net5 2.49984f
C162 net2 VDD 4.69968f
C163 net14 VDD 1.47514f
C164 net1 net12 0
C165 net7 net8 0.36743f
C166 net2 VINP 3.58972f
C167 VOUT net6 0.0931f
C168 EN_B MN_TAIL_BIAS 0.25789f
C169 net8 net5 0.20888f
C170 EN_B VBP_TOP 0.18339f
C171 VSTRP_IP net14 0.54919f
C172 net8 net12 0.00141f
C173 net2 net4 0.03057f
C174 net3 net9 0.122f
C175 net2 VBP_CASC 0.56306f
C176 EN_B net9 0.00264f
C177 net8 EN 0.39767f
C178 VDD VINP 17.8524f
C179 net7 net6 0.46156f
C180 net1 MN_TAIL_BIAS 0
C181 net6 net5 0.07806f
C182 VSTRP_IP VDD 4.91145f
C183 net7 VOUT 2.92486f
C184 VINP GNDA 7.76457f
C185 VINN GNDA 9.08141f
C186 MN_TAIL_BIAS GNDA 28.89236f
C187 VOUT GNDA 2.36611f
C188 EN GNDA 1.02684f
C189 VDD GNDA 0.1898p
C190 net12 GNDA 19.80223f
C191 net2 GNDA 4.90231f
C192 net1 GNDA 3.96475f
C193 net6 GNDA 3.8868f
C194 net15 GNDA 2.02279f
C195 VSTRP_OUT GNDA 0.18915f
C196 EN_B GNDA 5.53436f
C197 net14 GNDA 0.42294f
C198 VSTRP_IP GNDA 1.9546f
C199 net8 GNDA 11.58349f
C200 VBP_CASC GNDA 0.60431f
C201 VBP_TOP GNDA 8.55504f
C202 VBN_CASC GNDA 5.32414f
C203 net7 GNDA 0.02685f
C204 net4 GNDA 1.63662f
C205 net3 GNDA 1.70404f
C206 net9 GNDA 1.38903f
C207 net5 GNDA 3.2824f
C208 net5.t7 GNDA 0.0097f
C209 net5.n0 GNDA 0.02121f
C210 net5.n1 GNDA 1.79105f
C211 net5.t11 GNDA 0.20907f
C212 net5.t0 GNDA 0.0097f
C213 net5.t1 GNDA 0.0097f
C214 net5.n2 GNDA 0.02121f
C215 net5.n3 GNDA 0.92502f
C216 net5.t2 GNDA 0.0097f
C217 net5.t3 GNDA 0.0097f
C218 net5.n4 GNDA 0.02121f
C219 net5.n5 GNDA 0.6159f
C220 net5.t4 GNDA 0.0097f
C221 net5.t5 GNDA 0.0097f
C222 net5.n6 GNDA 0.02121f
C223 net5.n7 GNDA 0.6159f
C224 net5.t23 GNDA 1.03458f
C225 net5.n8 GNDA 0.42035f
C226 net5.t22 GNDA 1.03458f
C227 net5.n9 GNDA 0.32994f
C228 net5.t21 GNDA 1.03458f
C229 net5.n10 GNDA 0.32994f
C230 net5.t20 GNDA 1.03458f
C231 net5.n11 GNDA 0.32994f
C232 net5.t19 GNDA 1.03458f
C233 net5.n12 GNDA 0.32994f
C234 net5.t18 GNDA 1.03458f
C235 net5.n13 GNDA 0.32994f
C236 net5.t17 GNDA 1.03458f
C237 net5.n14 GNDA 0.32994f
C238 net5.t16 GNDA 1.03458f
C239 net5.n15 GNDA 0.32994f
C240 net5.t15 GNDA 1.03458f
C241 net5.n16 GNDA 0.32994f
C242 net5.t14 GNDA 1.03458f
C243 net5.n17 GNDA 0.32994f
C244 net5.t13 GNDA 1.03458f
C245 net5.n18 GNDA 0.41568f
C246 net5.t12 GNDA 1.27219f
C247 net5.t8 GNDA 0.0379f
C248 net5.n19 GNDA 1.59481f
C249 net5.t9 GNDA 0.0097f
C250 net5.t10 GNDA 0.0097f
C251 net5.n20 GNDA 0.0276f
C252 net5.n21 GNDA 2.05919f
C253 net5.n22 GNDA 2.60397f
C254 net5.t6 GNDA 0.0097f
C255 net9.t2 GNDA 0.05893f
C256 net9.n0 GNDA 0.23746f
C257 net9.t1 GNDA 0.17742f
C258 net9.t12 GNDA 1.60846f
C259 net9.t11 GNDA 1.30804f
C260 net9.n1 GNDA 0.52555f
C261 net9.t10 GNDA 1.30804f
C262 net9.n2 GNDA 0.41716f
C263 net9.t9 GNDA 1.30804f
C264 net9.n3 GNDA 0.4012f
C265 net9.t0 GNDA 1.30804f
C266 net9.n4 GNDA 0.38423f
C267 net9.t8 GNDA 1.30804f
C268 net9.n5 GNDA 0.43413f
C269 net9.t7 GNDA 1.30804f
C270 net9.n6 GNDA 0.43413f
C271 net9.t6 GNDA 1.30804f
C272 net9.n7 GNDA 0.41716f
C273 net9.t5 GNDA 1.30804f
C274 net9.n8 GNDA 0.52555f
C275 net9.t4 GNDA 1.60846f
C276 net9.n9 GNDA 0.11834f
C277 net9.n10 GNDA 4.26733f
C278 net9.t3 GNDA 0.2593f
C279 net9.n11 GNDA 5.6577f
C280 net3.t20 GNDA 0.07059f
C281 net3.n0 GNDA 0.20939f
C282 net3.n1 GNDA 2.29079f
C283 net3.t18 GNDA 0.30127f
C284 net3.n2 GNDA 1.488f
C285 net3.t21 GNDA 0.38525f
C286 net3.t9 GNDA 0.23232f
C287 net3.n3 GNDA 1.16871f
C288 net3.t10 GNDA 0.05647f
C289 net3.t0 GNDA 0.05647f
C290 net3.n4 GNDA 0.12016f
C291 net3.n5 GNDA 0.76342f
C292 net3.t4 GNDA 0.05342f
C293 net3.n6 GNDA 0.59118f
C294 net3.t12 GNDA 0.05647f
C295 net3.t13 GNDA 0.05647f
C296 net3.n7 GNDA 0.12016f
C297 net3.n8 GNDA 0.76342f
C298 net3.t6 GNDA 0.05342f
C299 net3.n9 GNDA 0.59118f
C300 net3.t11 GNDA 0.25325f
C301 net3.t3 GNDA 0.05468f
C302 net3.n10 GNDA 0.66528f
C303 net3.t1 GNDA 0.01412f
C304 net3.t5 GNDA 0.01412f
C305 net3.n11 GNDA 0.03031f
C306 net3.n12 GNDA 0.33545f
C307 net3.t2 GNDA 0.01412f
C308 net3.t7 GNDA 0.01412f
C309 net3.n13 GNDA 0.03031f
C310 net3.n14 GNDA 0.33545f
C311 net3.t8 GNDA 0.05468f
C312 net3.n15 GNDA 1.57722f
C313 net3.t14 GNDA 0.07059f
C314 net3.t15 GNDA 0.07059f
C315 net3.n16 GNDA 0.20939f
C316 net3.n17 GNDA 2.58149f
C317 net3.t16 GNDA 0.07059f
C318 net3.t17 GNDA 0.07059f
C319 net3.n18 GNDA 0.30427f
C320 net3.n19 GNDA 1.62492f
C321 net3.n20 GNDA 0.41589f
C322 net3.t19 GNDA 0.07059f
C323 net4.t7 GNDA 0.0584f
C324 net4.n0 GNDA 0.71457f
C325 net4.t8 GNDA 0.05975f
C326 net4.t10 GNDA 0.05975f
C327 net4.n1 GNDA 0.16633f
C328 net4.t21 GNDA 0.05975f
C329 net4.t20 GNDA 0.05975f
C330 net4.n2 GNDA 0.12573f
C331 net4.n3 GNDA 1.03989f
C332 net4.t3 GNDA 0.05658f
C333 net4.t4 GNDA 0.05658f
C334 net4.n4 GNDA 0.22748f
C335 net4.t9 GNDA 0.05975f
C336 net4.t11 GNDA 0.05975f
C337 net4.n5 GNDA 0.14749f
C338 net4.n6 GNDA 1.25057f
C339 net4.t0 GNDA 0.0584f
C340 net4.n7 GNDA 1.54423f
C341 net4.t1 GNDA 0.01494f
C342 net4.t2 GNDA 0.01494f
C343 net4.n8 GNDA 0.03266f
C344 net4.n9 GNDA 0.47183f
C345 net4.t5 GNDA 0.01494f
C346 net4.t6 GNDA 0.01494f
C347 net4.n10 GNDA 0.03266f
C348 net4.n11 GNDA 0.47183f
C349 net4.t12 GNDA 0.40766f
C350 net4.t13 GNDA 0.07469f
C351 net4.t14 GNDA 0.07469f
C352 net4.n12 GNDA 0.22156f
C353 net4.n13 GNDA 2.42404f
C354 net4.t15 GNDA 0.31879f
C355 net4.n14 GNDA 1.33115f
C356 net4.n15 GNDA 1.35514f
C357 net4.t16 GNDA 0.07469f
C358 net4.t17 GNDA 0.07469f
C359 net4.n16 GNDA 0.32196f
C360 net4.t18 GNDA 0.07469f
C361 net4.t19 GNDA 0.07469f
C362 net4.n17 GNDA 0.22156f
C363 net4.n18 GNDA 2.52092f
C364 net4.n19 GNDA 0.51836f
C365 net7.t30 GNDA 0.12977f
C366 net7.n0 GNDA 0.32338f
C367 net7.n1 GNDA 1.74661f
C368 net7.t52 GNDA 0.12977f
C369 net7.t24 GNDA 0.12977f
C370 net7.n2 GNDA 0.35607f
C371 net7.t25 GNDA 0.12977f
C372 net7.t53 GNDA 0.12977f
C373 net7.n3 GNDA 0.32338f
C374 net7.n4 GNDA 2.32335f
C375 net7.t54 GNDA 0.12977f
C376 net7.t26 GNDA 0.12977f
C377 net7.n5 GNDA 0.32338f
C378 net7.n6 GNDA 1.32098f
C379 net7.t27 GNDA 0.12977f
C380 net7.t55 GNDA 0.12977f
C381 net7.n7 GNDA 0.32338f
C382 net7.n8 GNDA 1.32098f
C383 net7.t56 GNDA 0.12977f
C384 net7.t28 GNDA 0.12977f
C385 net7.n9 GNDA 0.32338f
C386 net7.n10 GNDA 1.32098f
C387 net7.t29 GNDA 0.12977f
C388 net7.t57 GNDA 0.12977f
C389 net7.n11 GNDA 0.32338f
C390 net7.n12 GNDA 1.32098f
C391 net7.t2 GNDA 0.25398f
C392 net7.n13 GNDA 1.42433f
C393 net7.t62 GNDA 0.06488f
C394 net7.t61 GNDA 0.06488f
C395 net7.n14 GNDA 0.15015f
C396 net7.n15 GNDA 0.97963f
C397 net7.t0 GNDA 0.25398f
C398 net7.n16 GNDA 1.08476f
C399 net7.t63 GNDA 0.25398f
C400 net7.n17 GNDA 1.08476f
C401 net7.t59 GNDA 0.06488f
C402 net7.t60 GNDA 0.06488f
C403 net7.n18 GNDA 0.15015f
C404 net7.n19 GNDA 1.68784f
C405 net7.t1 GNDA 0.26539f
C406 net7.t31 GNDA 0.12977f
C407 net7.t3 GNDA 0.12977f
C408 net7.n20 GNDA 0.35607f
C409 net7.t4 GNDA 0.12977f
C410 net7.t32 GNDA 0.12977f
C411 net7.n21 GNDA 0.32338f
C412 net7.n22 GNDA 2.32335f
C413 net7.t33 GNDA 0.12977f
C414 net7.t5 GNDA 0.12977f
C415 net7.n23 GNDA 0.32338f
C416 net7.n24 GNDA 1.32098f
C417 net7.t6 GNDA 0.12977f
C418 net7.t34 GNDA 0.12977f
C419 net7.n25 GNDA 0.32338f
C420 net7.n26 GNDA 1.32098f
C421 net7.t35 GNDA 0.12977f
C422 net7.t7 GNDA 0.12977f
C423 net7.n27 GNDA 0.32338f
C424 net7.n28 GNDA 1.32098f
C425 net7.t8 GNDA 0.12977f
C426 net7.t36 GNDA 0.12977f
C427 net7.n29 GNDA 0.32338f
C428 net7.n30 GNDA 1.32098f
C429 net7.t37 GNDA 0.12977f
C430 net7.t9 GNDA 0.12977f
C431 net7.n31 GNDA 0.32338f
C432 net7.n32 GNDA 1.74661f
C433 net7.n33 GNDA 3.25242f
C434 net7.t10 GNDA 0.12977f
C435 net7.t38 GNDA 0.12977f
C436 net7.n34 GNDA 0.35607f
C437 net7.t39 GNDA 0.12977f
C438 net7.t11 GNDA 0.12977f
C439 net7.n35 GNDA 0.32338f
C440 net7.n36 GNDA 2.32335f
C441 net7.t12 GNDA 0.12977f
C442 net7.t40 GNDA 0.12977f
C443 net7.n37 GNDA 0.32338f
C444 net7.n38 GNDA 1.32098f
C445 net7.t41 GNDA 0.12977f
C446 net7.t13 GNDA 0.12977f
C447 net7.n39 GNDA 0.32338f
C448 net7.n40 GNDA 1.32098f
C449 net7.t14 GNDA 0.12977f
C450 net7.t42 GNDA 0.12977f
C451 net7.n41 GNDA 0.32338f
C452 net7.n42 GNDA 1.32098f
C453 net7.t43 GNDA 0.12977f
C454 net7.t15 GNDA 0.12977f
C455 net7.n43 GNDA 0.32338f
C456 net7.n44 GNDA 1.32098f
C457 net7.t16 GNDA 0.12977f
C458 net7.t44 GNDA 0.12977f
C459 net7.n45 GNDA 0.32338f
C460 net7.n46 GNDA 1.74661f
C461 net7.n47 GNDA 1.0875f
C462 net7.t17 GNDA 0.12977f
C463 net7.t45 GNDA 0.12977f
C464 net7.n48 GNDA 0.35607f
C465 net7.t46 GNDA 0.12977f
C466 net7.t18 GNDA 0.12977f
C467 net7.n49 GNDA 0.32338f
C468 net7.n50 GNDA 2.32335f
C469 net7.t19 GNDA 0.12977f
C470 net7.t47 GNDA 0.12977f
C471 net7.n51 GNDA 0.32338f
C472 net7.n52 GNDA 1.32098f
C473 net7.t48 GNDA 0.12977f
C474 net7.t20 GNDA 0.12977f
C475 net7.n53 GNDA 0.32338f
C476 net7.n54 GNDA 1.32098f
C477 net7.t21 GNDA 0.12977f
C478 net7.t49 GNDA 0.12977f
C479 net7.n55 GNDA 0.32338f
C480 net7.n56 GNDA 1.32098f
C481 net7.t50 GNDA 0.12977f
C482 net7.t22 GNDA 0.12977f
C483 net7.n57 GNDA 0.32338f
C484 net7.n58 GNDA 1.32098f
C485 net7.t23 GNDA 0.12977f
C486 net7.t51 GNDA 0.12977f
C487 net7.n59 GNDA 0.32338f
C488 net7.n60 GNDA 1.74661f
C489 net7.n61 GNDA 1.0875f
C490 net7.n62 GNDA 0.66687f
C491 net7.t58 GNDA 0.12977f
C492 VBN_CASC.t1 GNDA 0.04681f
C493 VBN_CASC.n0 GNDA 0.20444f
C494 VBN_CASC.t2 GNDA 0.43043f
C495 VBN_CASC.t3 GNDA 0.24451f
C496 VBN_CASC.n1 GNDA 8.05786f
C497 VBN_CASC.n2 GNDA 2.58754f
C498 VBN_CASC.t16 GNDA 0.15459f
C499 VBN_CASC.t15 GNDA 0.12881f
C500 VBN_CASC.n3 GNDA 0.13759f
C501 VBN_CASC.t14 GNDA 0.12881f
C502 VBN_CASC.n4 GNDA 0.0862f
C503 VBN_CASC.t13 GNDA 0.12881f
C504 VBN_CASC.n5 GNDA 0.0862f
C505 VBN_CASC.t12 GNDA 0.12881f
C506 VBN_CASC.n6 GNDA 0.0862f
C507 VBN_CASC.t11 GNDA 0.12881f
C508 VBN_CASC.n7 GNDA 0.11391f
C509 VBN_CASC.t10 GNDA 0.12881f
C510 VBN_CASC.n8 GNDA 0.09398f
C511 VBN_CASC.t9 GNDA 0.12881f
C512 VBN_CASC.n9 GNDA 0.06378f
C513 VBN_CASC.t8 GNDA 0.12881f
C514 VBN_CASC.n10 GNDA 0.06378f
C515 VBN_CASC.t7 GNDA 0.12881f
C516 VBN_CASC.n11 GNDA 0.06378f
C517 VBN_CASC.t6 GNDA 0.12881f
C518 VBN_CASC.n12 GNDA 0.06378f
C519 VBN_CASC.t5 GNDA 0.12881f
C520 VBN_CASC.n13 GNDA 0.06378f
C521 VBN_CASC.t4 GNDA 0.12881f
C522 VBN_CASC.n14 GNDA 0.06378f
C523 VBN_CASC.t0 GNDA 0.12881f
C524 VBN_CASC.n15 GNDA 0.07046f
C525 VBP_TOP.t18 GNDA 0.03558f
C526 VBP_TOP.n0 GNDA 0.35084f
C527 VBP_TOP.t2 GNDA 0.1883f
C528 VBP_TOP.t3 GNDA 0.1883f
C529 VBP_TOP.n1 GNDA 0.95694f
C530 VBP_TOP.t4 GNDA 0.1883f
C531 VBP_TOP.t5 GNDA 0.1883f
C532 VBP_TOP.n2 GNDA 0.84573f
C533 VBP_TOP.n3 GNDA 1.5278f
C534 VBP_TOP.t6 GNDA 0.1883f
C535 VBP_TOP.t7 GNDA 0.1883f
C536 VBP_TOP.n4 GNDA 0.84573f
C537 VBP_TOP.n5 GNDA 2.45255f
C538 VBP_TOP.t8 GNDA 0.1883f
C539 VBP_TOP.t9 GNDA 0.1883f
C540 VBP_TOP.n6 GNDA 1.08217f
C541 VBP_TOP.n7 GNDA 1.04999f
C542 VBP_TOP.n8 GNDA 2.1859f
C543 VBP_TOP.t10 GNDA 0.1883f
C544 VBP_TOP.t11 GNDA 0.1883f
C545 VBP_TOP.n9 GNDA 0.95694f
C546 VBP_TOP.t12 GNDA 0.1883f
C547 VBP_TOP.t13 GNDA 0.1883f
C548 VBP_TOP.n10 GNDA 0.84573f
C549 VBP_TOP.n11 GNDA 1.5278f
C550 VBP_TOP.t14 GNDA 0.1883f
C551 VBP_TOP.t15 GNDA 0.1883f
C552 VBP_TOP.n12 GNDA 0.84573f
C553 VBP_TOP.n13 GNDA 2.45255f
C554 VBP_TOP.t16 GNDA 0.1883f
C555 VBP_TOP.t17 GNDA 0.1883f
C556 VBP_TOP.n14 GNDA 1.08217f
C557 VBP_TOP.n15 GNDA 1.20163f
C558 VBP_TOP.n16 GNDA 0.13883f
C559 VBP_TOP.t1 GNDA 0.13621f
C560 VBP_TOP.t28 GNDA 1.23481f
C561 VBP_TOP.t27 GNDA 1.00418f
C562 VBP_TOP.n17 GNDA 0.43272f
C563 VBP_TOP.t0 GNDA 1.00418f
C564 VBP_TOP.n18 GNDA 0.29497f
C565 VBP_TOP.t26 GNDA 1.00418f
C566 VBP_TOP.n19 GNDA 0.33327f
C567 VBP_TOP.t25 GNDA 1.00418f
C568 VBP_TOP.n20 GNDA 0.33327f
C569 VBP_TOP.t24 GNDA 1.00418f
C570 VBP_TOP.n21 GNDA 0.32025f
C571 VBP_TOP.t23 GNDA 1.00418f
C572 VBP_TOP.n22 GNDA 0.32025f
C573 VBP_TOP.t22 GNDA 1.00418f
C574 VBP_TOP.n23 GNDA 0.32025f
C575 VBP_TOP.t21 GNDA 1.00418f
C576 VBP_TOP.n24 GNDA 0.32025f
C577 VBP_TOP.t20 GNDA 1.00418f
C578 VBP_TOP.n25 GNDA 0.40347f
C579 VBP_TOP.t19 GNDA 1.23481f
C580 VBP_TOP.n26 GNDA 0.13235f
C581 VBP_CASC.t0 GNDA 0.08054f
C582 VBP_CASC.n0 GNDA 1.89836f
C583 VBP_CASC.t3 GNDA 0.26421f
C584 VBP_CASC.t2 GNDA 0.06818f
C585 VBP_CASC.t21 GNDA 0.20433f
C586 VBP_CASC.t20 GNDA 0.18528f
C587 VBP_CASC.n1 GNDA 0.16405f
C588 VBP_CASC.t19 GNDA 0.18528f
C589 VBP_CASC.n2 GNDA 0.09776f
C590 VBP_CASC.t18 GNDA 0.18528f
C591 VBP_CASC.n3 GNDA 0.12174f
C592 VBP_CASC.t17 GNDA 0.18528f
C593 VBP_CASC.n4 GNDA 0.12174f
C594 VBP_CASC.t16 GNDA 0.18528f
C595 VBP_CASC.n5 GNDA 0.09776f
C596 VBP_CASC.t15 GNDA 0.18528f
C597 VBP_CASC.n6 GNDA 0.09776f
C598 VBP_CASC.t14 GNDA 0.18528f
C599 VBP_CASC.n7 GNDA 0.12174f
C600 VBP_CASC.t13 GNDA 0.18528f
C601 VBP_CASC.n8 GNDA 0.12174f
C602 VBP_CASC.t12 GNDA 0.18528f
C603 VBP_CASC.n9 GNDA 0.09776f
C604 VBP_CASC.t11 GNDA 0.18528f
C605 VBP_CASC.n10 GNDA 0.09776f
C606 VBP_CASC.t10 GNDA 0.18528f
C607 VBP_CASC.n11 GNDA 0.12174f
C608 VBP_CASC.t9 GNDA 0.18528f
C609 VBP_CASC.n12 GNDA 0.12174f
C610 VBP_CASC.t8 GNDA 0.18528f
C611 VBP_CASC.n13 GNDA 0.09776f
C612 VBP_CASC.t7 GNDA 0.18528f
C613 VBP_CASC.n14 GNDA 0.09776f
C614 VBP_CASC.t6 GNDA 0.18528f
C615 VBP_CASC.n15 GNDA 0.13587f
C616 VBP_CASC.t5 GNDA 0.18528f
C617 VBP_CASC.n16 GNDA 0.13245f
C618 VBP_CASC.t4 GNDA 0.18528f
C619 VBP_CASC.n17 GNDA 0.09091f
C620 VBP_CASC.t1 GNDA 0.18528f
C621 VBP_CASC.n18 GNDA 0.09511f
C622 VBP_CASC.n19 GNDA 0.06852f
C623 VBP_CASC.n20 GNDA 7.74246f
C624 a_5739_8265.t0 GNDA 0.00598f
C625 a_5739_8265.t1 GNDA 0.00598f
C626 a_5881_8265.t0 GNDA 0.00603f
C627 a_5881_8265.t1 GNDA 0.00603f
C628 net8.t2 GNDA 0.02084f
C629 net8.n0 GNDA 0.06351f
C630 net8.t3 GNDA 0.08727f
C631 net8.t4 GNDA 0.04351f
C632 net8.n1 GNDA 0.35317f
C633 net8.n2 GNDA 1.21724f
C634 net8.t0 GNDA 0.09802f
C635 net8.n3 GNDA 2.15499f
C636 net8.t26 GNDA 0.22327f
C637 net8.n4 GNDA 0.33041f
C638 net8.t25 GNDA 0.22327f
C639 net8.n5 GNDA 0.37963f
C640 net8.t24 GNDA 0.22327f
C641 net8.n6 GNDA 0.37963f
C642 net8.t23 GNDA 0.22327f
C643 net8.n7 GNDA 0.3472f
C644 net8.t22 GNDA 0.22327f
C645 net8.n8 GNDA 0.3472f
C646 net8.t21 GNDA 0.22327f
C647 net8.n9 GNDA 0.3472f
C648 net8.t20 GNDA 0.22327f
C649 net8.n10 GNDA 0.3472f
C650 net8.t19 GNDA 0.22327f
C651 net8.n11 GNDA 0.37963f
C652 net8.t18 GNDA 0.22327f
C653 net8.n12 GNDA 0.37963f
C654 net8.t17 GNDA 0.22327f
C655 net8.n13 GNDA 0.33823f
C656 net8.t1 GNDA 0.22327f
C657 net8.n14 GNDA 0.29692f
C658 net8.t15 GNDA 0.22327f
C659 net8.t14 GNDA 0.22327f
C660 net8.t13 GNDA 0.22327f
C661 net8.t12 GNDA 0.22327f
C662 net8.t11 GNDA 0.22327f
C663 net8.t10 GNDA 0.22327f
C664 net8.t9 GNDA 0.22327f
C665 net8.t8 GNDA 0.22327f
C666 net8.t7 GNDA 0.22327f
C667 net8.t6 GNDA 0.22327f
C668 net8.t5 GNDA 0.22327f
C669 net8.t16 GNDA 0.29495f
C670 net8.n15 GNDA 0.19604f
C671 VSTRP_IP.t5 GNDA 0.06444f
C672 VSTRP_IP.t6 GNDA 0.28493f
C673 VSTRP_IP.t4 GNDA 0.06637f
C674 VSTRP_IP.t0 GNDA 0.06637f
C675 VSTRP_IP.n0 GNDA 0.16551f
C676 VSTRP_IP.n1 GNDA 2.08439f
C677 VSTRP_IP.t2 GNDA 0.06637f
C678 VSTRP_IP.t3 GNDA 0.06637f
C679 VSTRP_IP.n2 GNDA 0.16551f
C680 VSTRP_IP.n3 GNDA 1.18178f
C681 VSTRP_IP.t1 GNDA 0.06637f
C682 VSTRP_IP.t7 GNDA 0.06637f
C683 VSTRP_IP.n4 GNDA 0.16551f
C684 VSTRP_IP.n5 GNDA 1.31876f
C685 VSTRP_IP.t9 GNDA 0.08766f
C686 VSTRP_IP.t8 GNDA 0.08592f
C687 VSTRP_IP.n6 GNDA 0.71963f
C688 VSTRP_IP.n7 GNDA 0.84257f
C689 net14.t0 GNDA 0.16185f
C690 net14.t1 GNDA 0.15935f
C691 net14.n0 GNDA 0.99407f
C692 net14.n1 GNDA 0.64358f
C693 net14.t3 GNDA 0.1154f
C694 net14.t2 GNDA 0.11367f
C695 net14.n2 GNDA 0.98509f
C696 EN_B.t0 GNDA 0.05672f
C697 EN_B.t1 GNDA 0.06078f
C698 EN_B.n0 GNDA 1.09505f
C699 EN_B.t5 GNDA 0.0488f
C700 EN_B.t4 GNDA 0.30197f
C701 EN_B.t3 GNDA 0.48994f
C702 EN_B.n1 GNDA 0.21471f
C703 EN_B.n2 GNDA 0.75556f
C704 EN_B.t2 GNDA 1.34053f
C705 EN_B.n3 GNDA 1.26092f
C706 EN_B.n4 GNDA 0.38875f
C707 VSTRP_OUT.t0 GNDA 0.12096f
C708 VSTRP_OUT.t1 GNDA 0.12102f
C709 VSTRP_OUT.n0 GNDA 0.74377f
C710 VSTRP_OUT.n1 GNDA 0.81326f
C711 VSTRP_OUT.t3 GNDA 1.77706f
C712 VSTRP_OUT.n2 GNDA 0.62434f
C713 VSTRP_OUT.t2 GNDA 0.12708f
C714 net15.t1 GNDA 0.01783f
C715 net15.t0 GNDA 0.57292f
C716 net6.t0 GNDA 0.05767f
C717 net6.t14 GNDA 0.0543f
C718 net6.n0 GNDA 1.24404f
C719 net6.t4 GNDA 0.0543f
C720 net6.n1 GNDA 1.24404f
C721 net6.t3 GNDA 0.05767f
C722 net6.n2 GNDA 0.87072f
C723 net6.t5 GNDA 0.0708f
C724 net6.t15 GNDA 0.0708f
C725 net6.n3 GNDA 0.24333f
C726 net6.t22 GNDA 0.0708f
C727 net6.t9 GNDA 0.0708f
C728 net6.n4 GNDA 0.20751f
C729 net6.n5 GNDA 1.36253f
C730 net6.t12 GNDA 0.0708f
C731 net6.t20 GNDA 0.0708f
C732 net6.n6 GNDA 0.20751f
C733 net6.n7 GNDA 1.36253f
C734 net6.t18 GNDA 0.0708f
C735 net6.t7 GNDA 0.0708f
C736 net6.n8 GNDA 0.24333f
C737 net6.n9 GNDA 0.29788f
C738 net6.t19 GNDA 0.0708f
C739 net6.t11 GNDA 0.0708f
C740 net6.n10 GNDA 0.24333f
C741 net6.t10 GNDA 0.0708f
C742 net6.t21 GNDA 0.0708f
C743 net6.n11 GNDA 0.20751f
C744 net6.n12 GNDA 1.36253f
C745 net6.t17 GNDA 0.0708f
C746 net6.t8 GNDA 0.0708f
C747 net6.n13 GNDA 0.20751f
C748 net6.n14 GNDA 1.36253f
C749 net6.t6 GNDA 0.0708f
C750 net6.t16 GNDA 0.0708f
C751 net6.n15 GNDA 0.24333f
C752 net6.n16 GNDA 0.26837f
C753 net6.n17 GNDA 2.73774f
C754 net6.t23 GNDA 0.05767f
C755 net6.t13 GNDA 0.0543f
C756 net6.n18 GNDA 1.24404f
C757 net6.t2 GNDA 0.0543f
C758 net6.n19 GNDA 1.24404f
C759 net6.t1 GNDA 0.05767f
C760 net6.n20 GNDA 0.87072f
C761 net6.n21 GNDA 2.42272f
C762 net6.n22 GNDA 0.21016f
C763 a_16520_7509.t0 GNDA 0.30445f
C764 a_16520_7509.t1 GNDA 0.22335f
C765 a_8458_6199.t1 GNDA 0.19759f
C766 a_8458_6199.t0 GNDA 0.19758f
C767 net1.t0 GNDA 0.01459f
C768 net1.n0 GNDA 0.06027f
C769 net1.t2 GNDA 0.05734f
C770 net1.n1 GNDA 2.98546f
C771 net1.t26 GNDA 0.48382f
C772 net1.n2 GNDA 1.49516f
C773 net1.t13 GNDA 0.11672f
C774 net1.t18 GNDA 0.11672f
C775 net1.n3 GNDA 0.2948f
C776 net1.n4 GNDA 1.73733f
C777 net1.t17 GNDA 0.11672f
C778 net1.t14 GNDA 0.11672f
C779 net1.n5 GNDA 0.2948f
C780 net1.n6 GNDA 2.86783f
C781 net1.t33 GNDA 0.11672f
C782 net1.t8 GNDA 0.11672f
C783 net1.n7 GNDA 0.36792f
C784 net1.t11 GNDA 0.11672f
C785 net1.t7 GNDA 0.11672f
C786 net1.n8 GNDA 0.2948f
C787 net1.n9 GNDA 1.79614f
C788 net1.t23 GNDA 0.11672f
C789 net1.t25 GNDA 0.11672f
C790 net1.n10 GNDA 0.2948f
C791 net1.n11 GNDA 1.73733f
C792 net1.t21 GNDA 0.11672f
C793 net1.t10 GNDA 0.11672f
C794 net1.n12 GNDA 0.2948f
C795 net1.n13 GNDA 2.9173f
C796 net1.t31 GNDA 0.5519f
C797 net1.n14 GNDA 1.34231f
C798 net1.t24 GNDA 0.11672f
C799 net1.t12 GNDA 0.11672f
C800 net1.n15 GNDA 0.2948f
C801 net1.n16 GNDA 1.79614f
C802 net1.t16 GNDA 0.11672f
C803 net1.t19 GNDA 0.11672f
C804 net1.n17 GNDA 0.2948f
C805 net1.n18 GNDA 1.73733f
C806 net1.t34 GNDA 0.11672f
C807 net1.t32 GNDA 0.11672f
C808 net1.n19 GNDA 0.2948f
C809 net1.n20 GNDA 2.9173f
C810 net1.t28 GNDA 0.5519f
C811 net1.n21 GNDA 0.95207f
C812 net1.t30 GNDA 0.48382f
C813 net1.n22 GNDA 1.44182f
C814 net1.t22 GNDA 0.11672f
C815 net1.t15 GNDA 0.11672f
C816 net1.n23 GNDA 0.2948f
C817 net1.n24 GNDA 1.73733f
C818 net1.t9 GNDA 0.11672f
C819 net1.t29 GNDA 0.11672f
C820 net1.n25 GNDA 0.2948f
C821 net1.n26 GNDA 2.86783f
C822 net1.t27 GNDA 0.11672f
C823 net1.t20 GNDA 0.11672f
C824 net1.n27 GNDA 0.36792f
C825 net1.n28 GNDA 0.82153f
C826 net1.t4 GNDA 0.05734f
C827 net1.n29 GNDA 1.6154f
C828 net1.t5 GNDA 0.05734f
C829 net1.n30 GNDA 0.92195f
C830 net1.t35 GNDA 0.05867f
C831 net1.n31 GNDA 1.17649f
C832 net1.t36 GNDA 0.01459f
C833 net1.t3 GNDA 0.01459f
C834 net1.n32 GNDA 0.03563f
C835 net1.n33 GNDA 2.76034f
C836 net1.t1 GNDA 0.06963f
C837 net1.n34 GNDA 0.94074f
C838 net1.n35 GNDA 0.84092f
C839 net1.t6 GNDA 0.01459f
C840 net2.t0 GNDA 0.01464f
C841 net2.n0 GNDA 0.06329f
C842 net2.t3 GNDA 0.05899f
C843 net2.n1 GNDA 3.20824f
C844 net2.t27 GNDA 0.11709f
C845 net2.t21 GNDA 0.11709f
C846 net2.n2 GNDA 0.36908f
C847 net2.t19 GNDA 0.11709f
C848 net2.t29 GNDA 0.11709f
C849 net2.n3 GNDA 0.29573f
C850 net2.n4 GNDA 2.87691f
C851 net2.t16 GNDA 0.11709f
C852 net2.t4 GNDA 0.11709f
C853 net2.n5 GNDA 0.29573f
C854 net2.n6 GNDA 1.74283f
C855 net2.t8 GNDA 0.48535f
C856 net2.n7 GNDA 1.62171f
C857 net2.t15 GNDA 0.55365f
C858 net2.t14 GNDA 0.11709f
C859 net2.t12 GNDA 0.11709f
C860 net2.n8 GNDA 0.29573f
C861 net2.n9 GNDA 2.92654f
C862 net2.t9 GNDA 0.11709f
C863 net2.t30 GNDA 0.11709f
C864 net2.n10 GNDA 0.29573f
C865 net2.n11 GNDA 1.74283f
C866 net2.t7 GNDA 0.11709f
C867 net2.t31 GNDA 0.11709f
C868 net2.n12 GNDA 0.29573f
C869 net2.n13 GNDA 1.90244f
C870 net2.n14 GNDA 1.43907f
C871 net2.t28 GNDA 0.55365f
C872 net2.t24 GNDA 0.11709f
C873 net2.t26 GNDA 0.11709f
C874 net2.n15 GNDA 0.29573f
C875 net2.n16 GNDA 2.92654f
C876 net2.t13 GNDA 0.11709f
C877 net2.t11 GNDA 0.11709f
C878 net2.n17 GNDA 0.29573f
C879 net2.n18 GNDA 1.74283f
C880 net2.t20 GNDA 0.11709f
C881 net2.t17 GNDA 0.11709f
C882 net2.n19 GNDA 0.29573f
C883 net2.n20 GNDA 1.90244f
C884 net2.n21 GNDA 1.01194f
C885 net2.t25 GNDA 0.11709f
C886 net2.t23 GNDA 0.11709f
C887 net2.n22 GNDA 0.36908f
C888 net2.t18 GNDA 0.11709f
C889 net2.t5 GNDA 0.11709f
C890 net2.n23 GNDA 0.29573f
C891 net2.n24 GNDA 2.87691f
C892 net2.t10 GNDA 0.11709f
C893 net2.t22 GNDA 0.11709f
C894 net2.n25 GNDA 0.29573f
C895 net2.n26 GNDA 1.74283f
C896 net2.t6 GNDA 0.48535f
C897 net2.n27 GNDA 1.57007f
C898 net2.n28 GNDA 0.97098f
C899 net2.t1 GNDA 0.01464f
C900 net2.t33 GNDA 0.01464f
C901 net2.n29 GNDA 0.03857f
C902 net2.t32 GNDA 0.05613f
C903 net2.n30 GNDA 2.30496f
C904 net2.n31 GNDA 1.36342f
C905 net2.t35 GNDA 0.07229f
C906 net2.t36 GNDA 0.01464f
C907 net2.t34 GNDA 0.01464f
C908 net2.n32 GNDA 0.03745f
C909 net2.n33 GNDA 2.97815f
C910 net2.n34 GNDA 1.11085f
C911 net2.n35 GNDA 1.00632f
C912 net2.t2 GNDA 0.01464f
C913 net12.t16 GNDA 1.7555f
C914 net12.t0 GNDA 1.03017f
C915 net12.t6 GNDA 0.14534f
C916 net12.t12 GNDA 0.14534f
C917 net12.n0 GNDA 0.66457f
C918 net12.n1 GNDA 1.68532f
C919 net12.t4 GNDA 0.85227f
C920 net12.n2 GNDA 1.14097f
C921 net12.t15 GNDA 0.85227f
C922 net12.n3 GNDA 1.14097f
C923 net12.t10 GNDA 0.14534f
C924 net12.t1 GNDA 0.14534f
C925 net12.n4 GNDA 0.66457f
C926 net12.n5 GNDA 0.98733f
C927 net12.t13 GNDA 0.86272f
C928 net12.n6 GNDA 0.86545f
C929 net12.n7 GNDA 1.18535f
C930 net12.t3 GNDA 1.03017f
C931 net12.t11 GNDA 0.14534f
C932 net12.t2 GNDA 0.14534f
C933 net12.n8 GNDA 0.66457f
C934 net12.n9 GNDA 1.68532f
C935 net12.t14 GNDA 0.85227f
C936 net12.n10 GNDA 1.14097f
C937 net12.t5 GNDA 0.85227f
C938 net12.n11 GNDA 1.14097f
C939 net12.t8 GNDA 0.14534f
C940 net12.t7 GNDA 0.14534f
C941 net12.n12 GNDA 0.66457f
C942 net12.n13 GNDA 0.98733f
C943 net12.t9 GNDA 0.86272f
C944 net12.n14 GNDA 0.86545f
C945 net12.n15 GNDA 0.427f
C946 a_8836_4519.t1 GNDA 0.34336f
C947 a_8836_4519.t0 GNDA 0.34312f
C948 a_9214_6199.t1 GNDA 0.33418f
C949 a_9214_6199.t0 GNDA 0.33415f
C950 a_9592_4519.t1 GNDA 0.38294f
C951 a_9592_4519.t0 GNDA 0.38268f
C952 a_9970_6199.t1 GNDA 0.39274f
C953 a_9970_6199.t0 GNDA 0.39272f
C954 a_10348_4519.t1 GNDA 0.35774f
C955 a_10348_4519.t0 GNDA 0.35749f
C956 a_10726_6199.t1 GNDA 0.19932f
C957 a_10726_6199.t0 GNDA 0.19931f
C958 a_11104_4519.t1 GNDA 0.39284f
C959 a_11104_4519.t0 GNDA 0.39257f
C960 a_11860_6329.t1 GNDA 0.2467f
C961 a_11860_6329.t0 GNDA 0.24669f
C962 a_12238_4519.t1 GNDA 0.34218f
C963 a_12238_4519.t0 GNDA 0.34194f
C964 a_12616_6329.t1 GNDA 0.32554f
C965 a_12616_6329.t0 GNDA 0.32552f
C966 a_12994_4519.t1 GNDA 0.32597f
C967 a_12994_4519.t0 GNDA 0.32575f
C968 a_13372_6329.t1 GNDA 0.32056f
C969 a_13372_6329.t0 GNDA 0.32054f
C970 a_13750_4519.t1 GNDA 0.32176f
C971 a_13750_4519.t0 GNDA 0.32154f
C972 a_14128_6329.t1 GNDA 0.33283f
C973 a_14128_6329.t0 GNDA 0.33281f
C974 a_14506_4519.t1 GNDA 0.20741f
C975 a_14506_4519.t0 GNDA 0.20727f
C976 a_15596_6577.t0 GNDA 0.04153f
C977 a_15596_6577.t1 GNDA 0.04153f
C978 a_15904_6577.t0 GNDA 0.03716f
C979 a_15904_6577.t1 GNDA 0.03716f
C980 a_16212_6577.t0 GNDA 0.03585f
C981 a_16212_6577.t1 GNDA 0.03585f
C982 a_16520_6577.t0 GNDA 0.0312f
C983 a_16520_6577.t1 GNDA 0.0312f
C984 a_15442_4519.t0 GNDA 0.03311f
C985 a_15442_4519.t1 GNDA 0.03311f
C986 a_15750_4519.t0 GNDA 0.03521f
C987 a_15750_4519.t1 GNDA 0.03521f
C988 a_16058_4519.t0 GNDA 0.03501f
C989 a_16058_4519.t1 GNDA 0.03501f
C990 a_16366_4519.t0 GNDA 0.03476f
C991 a_16366_4519.t1 GNDA 0.03476f
C992 a_16674_4519.t0 GNDA 0.03063f
C993 a_16674_4519.t1 GNDA 0.03063f
C994 a_4949_1601.t0 GNDA 0.00285f
C995 a_4949_1601.t1 GNDA 0.00285f
C996 a_5091_1601.t0 GNDA 0.0029f
C997 a_5091_1601.t1 GNDA 0.0029f
C998 a_5233_1601.t0 GNDA 0.00296f
C999 a_5233_1601.t1 GNDA 0.00296f
C1000 a_5375_1601.t0 GNDA 0.00309f
C1001 a_5375_1601.t1 GNDA 0.00309f
C1002 a_5517_1601.t0 GNDA 0.00332f
C1003 a_5517_1601.t1 GNDA 0.00332f
C1004 a_5659_1601.t0 GNDA 0.00371f
C1005 a_5659_1601.t1 GNDA 0.00371f
C1006 a_5801_1601.t0 GNDA 0.0046f
C1007 a_5801_1601.t1 GNDA 0.0046f
C1008 VDD.t19 GNDA 0.00981f
C1009 VDD.t11 GNDA 0.00981f
C1010 VDD.n0 GNDA 0.02038f
C1011 VDD.n1 GNDA 0.16253f
C1012 VDD.n2 GNDA 0.31528f
C1013 VDD.n3 GNDA 2.68864f
C1014 VDD.n4 GNDA -0.08444f
C1015 VDD.n5 GNDA 2.68864f
C1016 VDD.t64 GNDA 3.41937f
C1017 VDD.t71 GNDA 3.21637f
C1018 VDD.t70 GNDA 3.21637f
C1019 VDD.t63 GNDA 3.21637f
C1020 VDD.t62 GNDA 3.21637f
C1021 VDD.t69 GNDA 3.21637f
C1022 VDD.t68 GNDA 2.41228f
C1023 VDD.t65 GNDA 3.41937f
C1024 VDD.t58 GNDA 3.21637f
C1025 VDD.t59 GNDA 3.21637f
C1026 VDD.t66 GNDA 3.21637f
C1027 VDD.t67 GNDA 3.21637f
C1028 VDD.t60 GNDA 3.21637f
C1029 VDD.t61 GNDA 2.41228f
C1030 VDD.n6 GNDA 0.5375f
C1031 VDD.n7 GNDA 1.60819f
C1032 VDD.n8 GNDA 0.5375f
C1033 VDD.n9 GNDA 0.31528f
C1034 VDD.n10 GNDA 0.69114f
C1035 VDD.t48 GNDA 0.0093f
C1036 VDD.n11 GNDA 0.16036f
C1037 VDD.t108 GNDA 0.35928f
C1038 VDD.t7 GNDA 0.00981f
C1039 VDD.t102 GNDA 0.00981f
C1040 VDD.n12 GNDA 0.02038f
C1041 VDD.t9 GNDA 0.00981f
C1042 VDD.t51 GNDA 0.00981f
C1043 VDD.n13 GNDA 0.02038f
C1044 VDD.t98 GNDA 0.00981f
C1045 VDD.t114 GNDA 0.00981f
C1046 VDD.n14 GNDA 0.02038f
C1047 VDD.t27 GNDA 0.00981f
C1048 VDD.t100 GNDA 0.00981f
C1049 VDD.n15 GNDA 0.02038f
C1050 VDD.t82 GNDA 0.04159f
C1051 VDD.n16 GNDA 0.62984f
C1052 VDD.n17 GNDA 0.1588f
C1053 VDD.n18 GNDA 0.16459f
C1054 VDD.n19 GNDA 0.15429f
C1055 VDD.t109 GNDA 0.00981f
C1056 VDD.t40 GNDA 0.00981f
C1057 VDD.n20 GNDA 0.02038f
C1058 VDD.n21 GNDA 0.05805f
C1059 VDD.t74 GNDA 0.03683f
C1060 VDD.n22 GNDA 0.05371f
C1061 VDD.t78 GNDA 0.00931f
C1062 VDD.t0 GNDA 0.58102f
C1063 VDD.t117 GNDA 0.34166f
C1064 VDD.t118 GNDA 0.52095f
C1065 VDD.t119 GNDA 0.52095f
C1066 VDD.t120 GNDA 0.52095f
C1067 VDD.t121 GNDA 0.52095f
C1068 VDD.t122 GNDA 0.52095f
C1069 VDD.t123 GNDA 0.52095f
C1070 VDD.t124 GNDA 0.52095f
C1071 VDD.t125 GNDA 0.43638f
C1072 VDD.t126 GNDA 0.62832f
C1073 VDD.n23 GNDA 0.76118f
C1074 VDD.n24 GNDA 0.09141f
C1075 VDD.t73 GNDA 0.00981f
C1076 VDD.t88 GNDA 0.00981f
C1077 VDD.n25 GNDA 0.02104f
C1078 VDD.t115 GNDA 1.9415f
C1079 VDD.t34 GNDA 0.95807f
C1080 VDD.t75 GNDA 0.95807f
C1081 VDD.t103 GNDA 1.56814f
C1082 VDD.t96 GNDA 2.18243f
C1083 VDD.t110 GNDA 1.73862f
C1084 VDD.t16 GNDA 1.17504f
C1085 VDD.t81 GNDA 0.64529f
C1086 VDD.t37 GNDA 0.76082f
C1087 VDD.t24 GNDA 0.69601f
C1088 VDD.t26 GNDA 0.20148f
C1089 VDD.t14 GNDA 0.64529f
C1090 VDD.t101 GNDA 0.64529f
C1091 VDD.t2 GNDA 0.64529f
C1092 VDD.t6 GNDA 0.67065f
C1093 VDD.t77 GNDA 0.81154f
C1094 VDD.t50 GNDA 0.67065f
C1095 VDD.t28 GNDA 0.64529f
C1096 VDD.t8 GNDA 0.64529f
C1097 VDD.t93 GNDA 0.81154f
C1098 VDD.t113 GNDA 0.81154f
C1099 VDD.t87 GNDA 0.64529f
C1100 VDD.t97 GNDA 0.64529f
C1101 VDD.t72 GNDA 0.64529f
C1102 VDD.t99 GNDA 0.64529f
C1103 VDD.t12 GNDA 0.49453f
C1104 VDD.n26 GNDA 0.14635f
C1105 VDD.n27 GNDA -0.42188f
C1106 VDD.t25 GNDA 0.00981f
C1107 VDD.t13 GNDA 0.00981f
C1108 VDD.n28 GNDA 0.02104f
C1109 VDD.n29 GNDA 0.10975f
C1110 VDD.t17 GNDA 0.00981f
C1111 VDD.t38 GNDA 0.00981f
C1112 VDD.n30 GNDA 0.02104f
C1113 VDD.n31 GNDA 0.01955f
C1114 VDD.t104 GNDA 0.02927f
C1115 VDD.t116 GNDA 0.02927f
C1116 VDD.n32 GNDA 0.1143f
C1117 VDD.t35 GNDA 0.02927f
C1118 VDD.n33 GNDA 0.02235f
C1119 VDD.n34 GNDA 0.07308f
C1120 VDD.n35 GNDA 0.05146f
C1121 VDD.t76 GNDA 0.02927f
C1122 VDD.n36 GNDA 0.07308f
C1123 VDD.n37 GNDA 0.0341f
C1124 VDD.n38 GNDA 0.08053f
C1125 VDD.n39 GNDA 0.07308f
C1126 VDD.n40 GNDA 0.04586f
C1127 VDD.t111 GNDA 0.03683f
C1128 VDD.n41 GNDA 0.10001f
C1129 VDD.n42 GNDA 0.06242f
C1130 VDD.n43 GNDA 0.0502f
C1131 VDD.n44 GNDA 0.09618f
C1132 VDD.n45 GNDA 0.09255f
C1133 VDD.n46 GNDA 0.08682f
C1134 VDD.n47 GNDA 0.09618f
C1135 VDD.n48 GNDA 0.02881f
C1136 VDD.n49 GNDA 0.05607f
C1137 VDD.n50 GNDA 0.09618f
C1138 VDD.n51 GNDA 0.05779f
C1139 VDD.t94 GNDA 0.00981f
C1140 VDD.t29 GNDA 0.00981f
C1141 VDD.n52 GNDA 0.02104f
C1142 VDD.n53 GNDA 0.09618f
C1143 VDD.n54 GNDA 0.09438f
C1144 VDD.n55 GNDA 0.07114f
C1145 VDD.n56 GNDA 0.05447f
C1146 VDD.n57 GNDA 0.04054f
C1147 VDD.t3 GNDA 0.00981f
C1148 VDD.t15 GNDA 0.00981f
C1149 VDD.n58 GNDA 0.02104f
C1150 VDD.n59 GNDA 0.09618f
C1151 VDD.n60 GNDA 0.0351f
C1152 VDD.n61 GNDA 0.14606f
C1153 VDD.n62 GNDA 0.08822f
C1154 VDD.t80 GNDA 0.03678f
C1155 VDD.n63 GNDA 0.22327f
C1156 VDD.n64 GNDA 0.16169f
C1157 VDD.t55 GNDA 0.00981f
C1158 VDD.t45 GNDA 0.00981f
C1159 VDD.n65 GNDA 0.02038f
C1160 VDD.t21 GNDA 0.00981f
C1161 VDD.t90 GNDA 0.00981f
C1162 VDD.n66 GNDA 0.02038f
C1163 VDD.t57 GNDA 0.00981f
C1164 VDD.t84 GNDA 0.00981f
C1165 VDD.n67 GNDA 0.02038f
C1166 VDD.t107 GNDA 0.00981f
C1167 VDD.t5 GNDA 0.00981f
C1168 VDD.n68 GNDA 0.02038f
C1169 VDD.t53 GNDA 0.00981f
C1170 VDD.t43 GNDA 0.00981f
C1171 VDD.n69 GNDA 0.02038f
C1172 VDD.n70 GNDA 0.15302f
C1173 VDD.n71 GNDA 0.15302f
C1174 VDD.n72 GNDA 0.15302f
C1175 VDD.n73 GNDA 0.15302f
C1176 VDD.n74 GNDA 0.20329f
C1177 VDD.n75 GNDA 0.1989f
C1178 VDD.n76 GNDA 0.09886f
C1179 VDD.n77 GNDA 0.18495f
C1180 VDD.n78 GNDA -0.18474f
C1181 VDD.t39 GNDA 3.43778f
C1182 VDD.t54 GNDA 3.15459f
C1183 VDD.t79 GNDA 0.64529f
C1184 VDD.t44 GNDA 0.6002f
C1185 VDD.t105 GNDA 0.32405f
C1186 VDD.t46 GNDA 0.40014f
C1187 VDD.t47 GNDA 0.32124f
C1188 VDD.t20 GNDA 0.4734f
C1189 VDD.t32 GNDA 0.57484f
C1190 VDD.t86 GNDA 0.29306f
C1191 VDD.t89 GNDA 0.22261f
C1192 VDD.t49 GNDA 0.37477f
C1193 VDD.t1 GNDA 0.49312f
C1194 VDD.t56 GNDA 0.38041f
C1195 VDD.t92 GNDA 0.33251f
C1196 VDD.t112 GNDA 0.35082f
C1197 VDD.t10 GNDA 3.62376f
C1198 VDD.t18 GNDA 1.29058f
C1199 VDD.t42 GNDA 0.99752f
C1200 VDD.t30 GNDA 0.57484f
C1201 VDD.t33 GNDA 0.29306f
C1202 VDD.t52 GNDA 0.22261f
C1203 VDD.t95 GNDA 0.37477f
C1204 VDD.t36 GNDA 0.49312f
C1205 VDD.t4 GNDA 0.38041f
C1206 VDD.t23 GNDA 0.33251f
C1207 VDD.t85 GNDA 0.44522f
C1208 VDD.t31 GNDA 0.31278f
C1209 VDD.t106 GNDA 0.22261f
C1210 VDD.t22 GNDA 0.51285f
C1211 VDD.t41 GNDA 0.51285f
C1212 VDD.t83 GNDA 0.22261f
C1213 VDD.t91 GNDA 0.18457f
C1214 VDD.n79 GNDA -0.15828f
C1215 VDD.n80 GNDA 0.31373f
C1216 VDD.n81 GNDA 0.46168f
C1217 EN.t5 GNDA 1.35683f
C1218 EN.t4 GNDA 1.30507f
C1219 EN.n0 GNDA 2.08729f
C1220 EN.t3 GNDA 0.25244f
C1221 EN.n1 GNDA 1.41828f
C1222 EN.t6 GNDA 1.30557f
C1223 EN.n2 GNDA 1.85904f
C1224 EN.t1 GNDA 0.06077f
C1225 EN.t2 GNDA 0.06061f
C1226 EN.n3 GNDA 0.56237f
C1227 EN.n4 GNDA 0.88609f
C1228 EN.t0 GNDA 0.07437f
C1229 EN.n5 GNDA 0.74635f
C1230 VOUT.t5 GNDA 0.01554f
C1231 VOUT.t2 GNDA 0.01554f
C1232 VOUT.n0 GNDA 0.03372f
C1233 VOUT.t1 GNDA 0.01554f
C1234 VOUT.t3 GNDA 0.01554f
C1235 VOUT.n1 GNDA 0.03336f
C1236 VOUT.n2 GNDA 0.76664f
C1237 VOUT.t7 GNDA 0.01554f
C1238 VOUT.t4 GNDA 0.01554f
C1239 VOUT.n3 GNDA 0.03336f
C1240 VOUT.n4 GNDA 0.44202f
C1241 VOUT.t8 GNDA 0.01554f
C1242 VOUT.t10 GNDA 0.01554f
C1243 VOUT.n5 GNDA 0.03336f
C1244 VOUT.n6 GNDA 2.64882f
C1245 VOUT.t0 GNDA 0.06381f
C1246 VOUT.t9 GNDA 0.06227f
C1247 VOUT.n7 GNDA 1.13279f
C1248 VOUT.t6 GNDA 0.06227f
C1249 VOUT.n8 GNDA 1.91486f
C1250 VOUT.n9 GNDA 6.7416f
C1251 MN_TAIL_BIAS.t9 GNDA 0.00779f
C1252 MN_TAIL_BIAS.t10 GNDA 0.00783f
C1253 MN_TAIL_BIAS.n0 GNDA 0.30029f
C1254 MN_TAIL_BIAS.t8 GNDA 0.02968f
C1255 MN_TAIL_BIAS.n1 GNDA 0.24688f
C1256 MN_TAIL_BIAS.n2 GNDA 0.53819f
C1257 MN_TAIL_BIAS.t7 GNDA 0.03709f
C1258 MN_TAIL_BIAS.t5 GNDA 0.03709f
C1259 MN_TAIL_BIAS.n3 GNDA 0.07419f
C1260 MN_TAIL_BIAS.n4 GNDA 0.23115f
C1261 MN_TAIL_BIAS.t19 GNDA 1.53648f
C1262 MN_TAIL_BIAS.t11 GNDA 1.53648f
C1263 MN_TAIL_BIAS.n5 GNDA 1.11415f
C1264 MN_TAIL_BIAS.t20 GNDA 1.53648f
C1265 MN_TAIL_BIAS.t12 GNDA 1.53648f
C1266 MN_TAIL_BIAS.n6 GNDA 1.07958f
C1267 MN_TAIL_BIAS.n7 GNDA 0.03879f
C1268 MN_TAIL_BIAS.t21 GNDA 1.53648f
C1269 MN_TAIL_BIAS.t13 GNDA 1.53648f
C1270 MN_TAIL_BIAS.n8 GNDA 1.07958f
C1271 MN_TAIL_BIAS.n9 GNDA 0.03731f
C1272 MN_TAIL_BIAS.t22 GNDA 1.53648f
C1273 MN_TAIL_BIAS.t14 GNDA 1.53648f
C1274 MN_TAIL_BIAS.n10 GNDA 1.07958f
C1275 MN_TAIL_BIAS.n11 GNDA 0.03975f
C1276 MN_TAIL_BIAS.t6 GNDA 1.53648f
C1277 MN_TAIL_BIAS.t0 GNDA 1.53648f
C1278 MN_TAIL_BIAS.n12 GNDA 1.07958f
C1279 MN_TAIL_BIAS.n13 GNDA 0.03042f
C1280 MN_TAIL_BIAS.t26 GNDA 1.53648f
C1281 MN_TAIL_BIAS.t18 GNDA 1.53648f
C1282 MN_TAIL_BIAS.n14 GNDA 1.11415f
C1283 MN_TAIL_BIAS.t25 GNDA 1.53648f
C1284 MN_TAIL_BIAS.t17 GNDA 1.53648f
C1285 MN_TAIL_BIAS.n15 GNDA 1.07958f
C1286 MN_TAIL_BIAS.n16 GNDA 0.03879f
C1287 MN_TAIL_BIAS.t24 GNDA 1.53648f
C1288 MN_TAIL_BIAS.t16 GNDA 1.53648f
C1289 MN_TAIL_BIAS.n17 GNDA 1.07958f
C1290 MN_TAIL_BIAS.n18 GNDA 0.03731f
C1291 MN_TAIL_BIAS.t23 GNDA 1.53648f
C1292 MN_TAIL_BIAS.t15 GNDA 1.53648f
C1293 MN_TAIL_BIAS.n19 GNDA 1.07958f
C1294 MN_TAIL_BIAS.n20 GNDA 0.03975f
C1295 MN_TAIL_BIAS.t4 GNDA 1.53648f
C1296 MN_TAIL_BIAS.t2 GNDA 1.53648f
C1297 MN_TAIL_BIAS.n21 GNDA 1.07958f
C1298 MN_TAIL_BIAS.n22 GNDA 0.03042f
C1299 MN_TAIL_BIAS.n23 GNDA 0.0638f
C1300 MN_TAIL_BIAS.t1 GNDA 0.03709f
C1301 MN_TAIL_BIAS.t3 GNDA 0.03709f
C1302 MN_TAIL_BIAS.n24 GNDA 0.07419f
C1303 MN_TAIL_BIAS.n25 GNDA 0.23115f
C1304 MN_TAIL_BIAS.n26 GNDA 0.2621f
C1305 VINN.n0 GNDA 0.2372f
C1306 VINN.t21 GNDA 1.35967f
C1307 VINN.t14 GNDA 1.35967f
C1308 VINN.t15 GNDA 1.35967f
C1309 VINN.n1 GNDA 0.49181f
C1310 VINN.n2 GNDA 0.11576f
C1311 VINN.t22 GNDA 1.35967f
C1312 VINN.t23 GNDA 1.35967f
C1313 VINN.t16 GNDA 1.35967f
C1314 VINN.t17 GNDA 1.35967f
C1315 VINN.n3 GNDA 0.49181f
C1316 VINN.n4 GNDA 0.11576f
C1317 VINN.t24 GNDA 1.35967f
C1318 VINN.t25 GNDA 1.35967f
C1319 VINN.t18 GNDA 1.35967f
C1320 VINN.t19 GNDA 1.35967f
C1321 VINN.n5 GNDA 0.49181f
C1322 VINN.t20 GNDA 1.4034f
C1323 VINN.n6 GNDA 0.56393f
C1324 VINN.t26 GNDA 1.35967f
C1325 VINN.t27 GNDA 1.35967f
C1326 VINN.n7 GNDA 0.49181f
C1327 VINN.n8 GNDA 0.49181f
C1328 VINN.n9 GNDA 0.21408f
C1329 VINN.n10 GNDA 0.11576f
C1330 VINN.n11 GNDA 0.11576f
C1331 VINN.n12 GNDA 0.49181f
C1332 VINN.n13 GNDA 0.49181f
C1333 VINN.n14 GNDA 0.49181f
C1334 VINN.n15 GNDA 0.11576f
C1335 VINN.n16 GNDA 0.11576f
C1336 VINN.n17 GNDA 0.11576f
C1337 VINN.n18 GNDA 0.49181f
C1338 VINN.n19 GNDA 0.49181f
C1339 VINN.n20 GNDA 0.49181f
C1340 VINN.n21 GNDA 0.11576f
C1341 VINN.n22 GNDA 0.11576f
C1342 VINN.n23 GNDA 0.11576f
C1343 VINN.n24 GNDA 0.49181f
C1344 VINN.n25 GNDA 0.56677f
C1345 VINN.n26 GNDA 0.20694f
C1346 VINN.n27 GNDA 0.11576f
C1347 VINN.n28 GNDA 0.11576f
C1348 VINN.n29 GNDA 0.11576f
C1349 VINN.n30 GNDA 0.11576f
C1350 VINN.n31 GNDA 0.11576f
C1351 VINN.n32 GNDA 0.11576f
C1352 VINN.n33 GNDA 0.11576f
C1353 VINN.n34 GNDA 0.11576f
C1354 VINN.n35 GNDA 0.11576f
C1355 VINN.n36 GNDA 0.11576f
C1356 VINN.n37 GNDA 0.21408f
C1357 VINN.t13 GNDA 1.4034f
C1358 VINN.n38 GNDA 0.56393f
C1359 VINN.t6 GNDA 1.35967f
C1360 VINN.n39 GNDA 0.49181f
C1361 VINN.t5 GNDA 1.35967f
C1362 VINN.n40 GNDA 0.49181f
C1363 VINN.t12 GNDA 1.35967f
C1364 VINN.n41 GNDA 0.49181f
C1365 VINN.t11 GNDA 1.35967f
C1366 VINN.n42 GNDA 0.49181f
C1367 VINN.t4 GNDA 1.35967f
C1368 VINN.n43 GNDA 0.49181f
C1369 VINN.t3 GNDA 1.35967f
C1370 VINN.n44 GNDA 0.49181f
C1371 VINN.t10 GNDA 1.35967f
C1372 VINN.n45 GNDA 0.49181f
C1373 VINN.t9 GNDA 1.35967f
C1374 VINN.n46 GNDA 0.49181f
C1375 VINN.t2 GNDA 1.35967f
C1376 VINN.n47 GNDA 0.49181f
C1377 VINN.t1 GNDA 1.35967f
C1378 VINN.n48 GNDA 0.49181f
C1379 VINN.t8 GNDA 1.35967f
C1380 VINN.n49 GNDA 0.49181f
C1381 VINN.t7 GNDA 1.35967f
C1382 VINN.n50 GNDA 0.49181f
C1383 VINN.t0 GNDA 1.35967f
C1384 VINN.n51 GNDA 0.56685f
C1385 VINN.n52 GNDA 0.23735f
C1386 VINN.n53 GNDA 0.54473f
C1387 VINN.n54 GNDA 0.27642f
C1388 VINN.t32 GNDA 0.89527f
C1389 VINN.t33 GNDA 0.89527f
C1390 VINN.t34 GNDA 0.89527f
C1391 VINN.n55 GNDA 0.45562f
C1392 VINN.t35 GNDA 0.95994f
C1393 VINN.n56 GNDA 0.62423f
C1394 VINN.n57 GNDA 0.28463f
C1395 VINN.n58 GNDA 0.45562f
C1396 VINN.n59 GNDA 0.47766f
C1397 VINN.n60 GNDA 0.20397f
C1398 VINN.n61 GNDA 0.25647f
C1399 VINN.t31 GNDA 0.92402f
C1400 VINN.n62 GNDA 0.45679f
C1401 VINN.t30 GNDA 0.89527f
C1402 VINN.n63 GNDA 0.45562f
C1403 VINN.t29 GNDA 0.89527f
C1404 VINN.n64 GNDA 0.45562f
C1405 VINN.t28 GNDA 0.89527f
C1406 VINN.n65 GNDA 0.38584f
C1407 VINN.n66 GNDA 0.21564f
C1408 VINN.n67 GNDA 0.59786f
C1409 VINN.n68 GNDA 1.83229f
C1410 VINP.n0 GNDA 0.11367f
C1411 VINP.t30 GNDA 0.94643f
C1412 VINP.n1 GNDA 0.40635f
C1413 VINP.n2 GNDA 0.20076f
C1414 VINP.t28 GNDA 0.99064f
C1415 VINP.n3 GNDA 0.46677f
C1416 VINP.t32 GNDA 0.94643f
C1417 VINP.n4 GNDA 0.40635f
C1418 VINP.t33 GNDA 0.94643f
C1419 VINP.n5 GNDA 0.40635f
C1420 VINP.t29 GNDA 0.94643f
C1421 VINP.n6 GNDA 0.40635f
C1422 VINP.n7 GNDA 0.10825f
C1423 VINP.n8 GNDA 0.10825f
C1424 VINP.n9 GNDA 0.10825f
C1425 VINP.t34 GNDA 0.94643f
C1426 VINP.n10 GNDA 0.40635f
C1427 VINP.t35 GNDA 0.94643f
C1428 VINP.n11 GNDA 0.40635f
C1429 VINP.t31 GNDA 0.94643f
C1430 VINP.n12 GNDA 0.39375f
C1431 VINP.n13 GNDA 0.53329f
C1432 VINP.n14 GNDA 0.14935f
C1433 VINP.n15 GNDA 0.48249f
C1434 VINP.t25 GNDA 1.43737f
C1435 VINP.n16 GNDA 0.58346f
C1436 VINP.n17 GNDA 0.26502f
C1437 VINP.t21 GNDA 1.47481f
C1438 VINP.n18 GNDA 0.61475f
C1439 VINP.t22 GNDA 1.43737f
C1440 VINP.n19 GNDA 0.58346f
C1441 VINP.t23 GNDA 1.43737f
C1442 VINP.n20 GNDA 0.58346f
C1443 VINP.t24 GNDA 1.43737f
C1444 VINP.n21 GNDA 0.58346f
C1445 VINP.n22 GNDA 0.21651f
C1446 VINP.n23 GNDA 0.21651f
C1447 VINP.n24 GNDA 0.21651f
C1448 VINP.t26 GNDA 1.43737f
C1449 VINP.n25 GNDA 0.58346f
C1450 VINP.t27 GNDA 1.43737f
C1451 VINP.n26 GNDA 0.72683f
C1452 VINP.t18 GNDA 1.26197f
C1453 VINP.t11 GNDA 1.26197f
C1454 VINP.n27 GNDA 0.98656f
C1455 VINP.n28 GNDA 0.31064f
C1456 VINP.n29 GNDA 0.30892f
C1457 VINP.t14 GNDA 1.26197f
C1458 VINP.t7 GNDA 1.26197f
C1459 VINP.n30 GNDA 1.08885f
C1460 VINP.n31 GNDA 0.53227f
C1461 VINP.t15 GNDA 1.26197f
C1462 VINP.t8 GNDA 1.26197f
C1463 VINP.n32 GNDA 0.98656f
C1464 VINP.n33 GNDA 0.31064f
C1465 VINP.t16 GNDA 1.26197f
C1466 VINP.t9 GNDA 1.26197f
C1467 VINP.n34 GNDA 0.98656f
C1468 VINP.n35 GNDA 0.31064f
C1469 VINP.t17 GNDA 1.26197f
C1470 VINP.t10 GNDA 1.26197f
C1471 VINP.n36 GNDA 0.98656f
C1472 VINP.n37 GNDA 0.31064f
C1473 VINP.n38 GNDA 0.21651f
C1474 VINP.n39 GNDA 0.21651f
C1475 VINP.n40 GNDA 0.21651f
C1476 VINP.t19 GNDA 1.26197f
C1477 VINP.t12 GNDA 1.26197f
C1478 VINP.n41 GNDA 0.98656f
C1479 VINP.n42 GNDA 0.31064f
C1480 VINP.t20 GNDA 1.26197f
C1481 VINP.t13 GNDA 1.26197f
C1482 VINP.n43 GNDA 0.98656f
C1483 VINP.n44 GNDA 0.18857f
C1484 VINP.n45 GNDA 0.46469f
C1485 VINP.n46 GNDA 0.21651f
C1486 VINP.t3 GNDA 1.43737f
C1487 VINP.n47 GNDA 0.58346f
C1488 VINP.t4 GNDA 1.43737f
C1489 VINP.t0 GNDA 1.47481f
C1490 VINP.n48 GNDA 0.61475f
C1491 VINP.t1 GNDA 1.43737f
C1492 VINP.n49 GNDA 0.58346f
C1493 VINP.t2 GNDA 1.43737f
C1494 VINP.n50 GNDA 0.58346f
C1495 VINP.n51 GNDA 0.26502f
C1496 VINP.n52 GNDA 0.21651f
C1497 VINP.n53 GNDA 0.21651f
C1498 VINP.n54 GNDA 0.58346f
C1499 VINP.t5 GNDA 1.43737f
C1500 VINP.n55 GNDA 0.58346f
C1501 VINP.t6 GNDA 1.43737f
C1502 VINP.n56 GNDA 0.72683f
C1503 VINP.n57 GNDA 0.48249f
C1504 VINP.n58 GNDA 0.9007f
.ends
