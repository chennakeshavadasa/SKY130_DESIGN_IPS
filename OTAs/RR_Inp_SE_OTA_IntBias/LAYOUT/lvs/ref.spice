** sch_path: /home/nithin/eda/designs/sky130/SKY130_DESIGN_IPS/OTAs/RR_Inp_SE_OTA_IntBias/SCH/Rail_to_Rail_IP_OP_OTA_with_Intrenal_Bias.sch
.subckt Rail_to_Rail_IP_OP_OTA_with_Intrenal_Bias VDD EN VINN VOUT VINP MN_TAIL_BIAS GNDA
*.PININFO VINP:I VINN:I VDD:I GNDA:I VOUT:O EN:I MN_TAIL_BIAS:B
XMN_BOT_L2 net2 net8 GNDA GNDA sky130_fd_pr__nfet_01v8 L=2 W=0.5 nf=1 m=6
XMN_CASC_L2 VOUT VBN_CASC net2 GNDA sky130_fd_pr__nfet_01v8 L=0.5 W=0.5 nf=1 m=3
XMN_BOT_L1 net1 net8 GNDA GNDA sky130_fd_pr__nfet_01v8 L=2 W=0.5 nf=1 m=6
XMN_CASC_L1 net5 VBN_CASC net1 GNDA sky130_fd_pr__nfet_01v8 L=0.5 W=0.5 nf=1 m=3
XMP_CASC_L2 VOUT VBP_CASC net4 VDD sky130_fd_pr__pfet_01v8 L=0.5 W=0.5 nf=1 m=8
XMP_CASC_L1 net5 VBP_CASC net3 VDD sky130_fd_pr__pfet_01v8 L=0.5 W=0.5 nf=1 m=8
XMP_TOP_L1 net3 net5 VDD VDD sky130_fd_pr__pfet_01v8 L=2 W=2 nf=1 m=6
XMN_A1 net3 VINP net6 GNDA sky130_fd_pr__nfet_01v8_lvt L=2 W=2.5 nf=1 m=8
XMN_A2 net4 VINN net6 GNDA sky130_fd_pr__nfet_01v8_lvt L=2 W=2.5 nf=1 m=8
XMP_A1 net1 VINP net7 VDD sky130_fd_pr__pfet_01v8_lvt L=2 W=4 nf=1 m=28
XMP_A2 net2 VINN net7 VDD sky130_fd_pr__pfet_01v8_lvt L=2 W=4 nf=1 m=28
XMP_PDIFF_BIAS net7 net9 VDD VDD sky130_fd_pr__pfet_01v8 L=2 W=2 nf=1 m=8
XMN_NDIFF_BIAS net6 net8 GNDA GNDA sky130_fd_pr__nfet_01v8 L=2 W=0.5 nf=1 m=8
XMP_PDIFF_BIAS_B net9 net9 VDD VDD sky130_fd_pr__pfet_01v8 L=2 W=2 nf=1
XMP_TOP_L2 net4 net5 VDD VDD sky130_fd_pr__pfet_01v8 L=2 W=2 nf=1 m=6
XMN_BIAS_SOURCE net9 net8 GNDA GNDA sky130_fd_pr__nfet_01v8 L=2 W=0.5 nf=1
XMN_BIAS_EXT net8 net8 GNDA GNDA sky130_fd_pr__nfet_01v8 L=2 W=0.5 nf=1
XMP_CASC_B_SOURCE VBN_CASC net9 VDD VDD sky130_fd_pr__pfet_01v8 L=2 W=2 nf=1
XMN_CASC_BIAS8 net16 VBN_CASC GNDA GNDA sky130_fd_pr__nfet_01v8 L=0.5 W=0.5 nf=1
XMN_CASC_B_SOURCE VBP_CASC net8 GNDA GNDA sky130_fd_pr__nfet_01v8 L=2 W=0.5 nf=1
XMP_CASC_BIAS1 net11 VBP_CASC VDD VDD sky130_fd_pr__pfet_01v8 L=0.5 W=0.5 nf=1
XMN_CASC_BIAS7 net17 VBN_CASC net16 GNDA sky130_fd_pr__nfet_01v8 L=0.5 W=0.5 nf=1
XMN_CASC_BIAS6 net18 VBN_CASC net17 GNDA sky130_fd_pr__nfet_01v8 L=0.5 W=0.5 nf=1
XMP_CASC_BIAS2 net10 VBP_CASC net11 VDD sky130_fd_pr__pfet_01v8 L=0.5 W=0.5 nf=1
XMP_CASC_BIAS3 VBP_CASC VBP_CASC net10 VDD sky130_fd_pr__pfet_01v8 L=0.5 W=0.5 nf=1
XMN_CASC_BIAS5 net19 VBN_CASC net18 GNDA sky130_fd_pr__nfet_01v8 L=0.5 W=0.5 nf=1
XMN_CASC_BIAS4 net20 VBN_CASC net19 GNDA sky130_fd_pr__nfet_01v8 L=0.5 W=0.5 nf=1
XMN_CASC_BIAS3 net21 VBN_CASC net20 GNDA sky130_fd_pr__nfet_01v8 L=0.5 W=0.5 nf=1
XMN_CASC_BIAS1 VBN_CASC VBN_CASC net22 GNDA sky130_fd_pr__nfet_01v8 L=0.5 W=0.5 nf=1
XMN_CASC_BIAS2 net22 VBN_CASC net21 GNDA sky130_fd_pr__nfet_01v8 L=0.5 W=0.5 nf=1
XMN_SW1 net8 EN_B GNDA GNDA sky130_fd_pr__nfet_01v8 L=1 W=1 nf=1
XMP_SW1 net9 EN VDD VDD sky130_fd_pr__pfet_01v8 L=2 W=2 nf=1
XMP_SW2 VBP_CASC EN VDD VDD sky130_fd_pr__pfet_01v8 L=2 W=2 nf=1
XMN_SW2 VBN_CASC EN_B GNDA GNDA sky130_fd_pr__nfet_01v8 L=2 W=1 nf=1
XMP_SW3 net5 EN VDD VDD sky130_fd_pr__pfet_01v8 L=2 W=2 nf=1
XM1 VBP_TOP MN_TAIL_BIAS net12 GNDA sky130_fd_pr__nfet_01v8 L=4 W=10 nf=1 m=16
XM3 VBP_TOP VBP_TOP VDD VDD sky130_fd_pr__pfet_01v8 L=2 W=2 nf=1
XM4 MN_TAIL_BIAS VBP_TOP VDD VDD sky130_fd_pr__pfet_01v8 L=2 W=2 nf=1
XM10 MN_TAIL_BIAS MN_TAIL_BIAS GNDA GNDA sky130_fd_pr__nfet_01v8 L=4 W=10 nf=1 m=4
XM16 MN_TAIL_BIAS EN_B GNDA GNDA sky130_fd_pr__nfet_01v8 L=6.4 W=0.5 nf=1
XR14 net23 net12 GNDA sky130_fd_pr__res_xhigh_po_1p41 L=6.4 mult=1
XR15 net24 net23 GNDA sky130_fd_pr__res_xhigh_po_1p41 L=6.4 mult=1
XR16 net25 net24 GNDA sky130_fd_pr__res_xhigh_po_1p41 L=6.4 mult=1
XR17 net26 net25 GNDA sky130_fd_pr__res_xhigh_po_1p41 L=6.4 mult=1
XR18 net27 net26 GNDA sky130_fd_pr__res_xhigh_po_1p41 L=6.4 mult=1
XR19 net28 net27 GNDA sky130_fd_pr__res_xhigh_po_1p41 L=6.4 mult=1
XR20 net29 net28 GNDA sky130_fd_pr__res_xhigh_po_1p41 L=6.4 mult=1
XR21 net30 net29 GNDA sky130_fd_pr__res_xhigh_po_1p41 L=6.4 mult=1
XR22 GNDA net30 GNDA sky130_fd_pr__res_xhigh_po_1p41 L=6.4 mult=1
XM15 VBP_TOP EN VDD VDD sky130_fd_pr__pfet_01v8 L=1 W=0.5 nf=1
XM2 VSTRP_IP VBP_TOP VDD VDD sky130_fd_pr__pfet_01v8 L=2 W=2 nf=1 m=7
XM19 VSTRP_IP VDD net31 GNDA sky130_fd_pr__nfet_01v8 L=10 W=0.5 nf=1
XM20 net31 VDD net32 GNDA sky130_fd_pr__nfet_01v8 L=10 W=0.5 nf=1
XM21 net32 VDD net33 GNDA sky130_fd_pr__nfet_01v8 L=10 W=0.5 nf=1
XM26 net33 VDD net34 GNDA sky130_fd_pr__nfet_01v8 L=10 W=0.5 nf=1
XM27 net34 VDD net35 GNDA sky130_fd_pr__nfet_01v8 L=10 W=0.5 nf=1
XM28 net35 VDD net36 GNDA sky130_fd_pr__nfet_01v8 L=10 W=0.5 nf=1
XM29 net36 VDD net37 GNDA sky130_fd_pr__nfet_01v8 L=10 W=0.5 nf=1
XM30 net37 VDD net38 GNDA sky130_fd_pr__nfet_01v8 L=10 W=0.5 nf=1
XM31 net38 VDD net39 GNDA sky130_fd_pr__nfet_01v8 L=10 W=0.5 nf=1
XM32 net39 VDD GNDA GNDA sky130_fd_pr__nfet_01v8 L=10 W=0.5 nf=1
XM12 MN_TAIL_BIAS VSTRP_OUT net15 VDD sky130_fd_pr__pfet_01v8 L=4 W=0.5 nf=1
XR24 net40 VDD GNDA sky130_fd_pr__res_xhigh_po_1p41 L=7.05 mult=1
XR25 net41 net40 GNDA sky130_fd_pr__res_xhigh_po_1p41 L=7.05 mult=1
XR26 net42 net41 GNDA sky130_fd_pr__res_xhigh_po_1p41 L=7.05 mult=1
XR27 net43 net42 GNDA sky130_fd_pr__res_xhigh_po_1p41 L=7.05 mult=1
XR28 net44 net43 GNDA sky130_fd_pr__res_xhigh_po_1p41 L=7.05 mult=1
XR29 net45 net44 GNDA sky130_fd_pr__res_xhigh_po_1p41 L=7.05 mult=1
XR30 net46 net45 GNDA sky130_fd_pr__res_xhigh_po_1p41 L=7.05 mult=1
XR31 net47 net46 GNDA sky130_fd_pr__res_xhigh_po_1p41 L=7.05 mult=1
XR34 net15 net47 GNDA sky130_fd_pr__res_xhigh_po_1p41 L=7.05 mult=1
XM5 EN_B EN GNDA GNDA sky130_fd_pr__nfet_01v8 L=0.15 W=1 nf=1
XM6 EN_B EN VDD VDD sky130_fd_pr__pfet_01v8 L=0.15 W=1 nf=1
XM38 VSTRP_OUT net14 net13 GNDA sky130_fd_pr__nfet_01v8 L=0.15 W=1 nf=1
XM39 net13 EN GNDA GNDA sky130_fd_pr__nfet_01v8 L=0.15 W=1 nf=1
XM42 net14 VSTRP_IP GNDA GNDA sky130_fd_pr__nfet_01v8 L=0.15 W=1 nf=1
XM43 net14 VSTRP_IP VDD VDD sky130_fd_pr__pfet_01v8 L=0.15 W=1 nf=1
XM13 VSTRP_OUT net14 VDD VDD sky130_fd_pr__pfet_01v8 L=0.15 W=1 nf=1
XM14 VSTRP_OUT EN_B VDD VDD sky130_fd_pr__pfet_01v8 L=0.15 W=1 nf=1
XM9 net8 VBP_TOP VDD VDD sky130_fd_pr__pfet_01v8 L=2 W=2 nf=1 m=2
.ends
